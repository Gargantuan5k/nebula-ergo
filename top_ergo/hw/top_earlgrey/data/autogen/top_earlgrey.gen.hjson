// Copyright lowRISC contributors (OpenTitan project).
// Licensed under the Apache License, Version 2.0, see LICENSE for details.
// SPDX-License-Identifier: Apache-2.0
//
// ------------------- W A R N I N G: A U T O - G E N E R A T E D   C O D E !! -------------------//
// PLEASE DO NOT HAND-EDIT THIS FILE. IT HAS BEEN AUTO-GENERATED WITH THE FOLLOWING COMMAND:
//
// util/topgen.py -t hw/top_earlgrey/data/top_earlgrey.hjson \
//                -o hw/top_earlgrey/ \
//                --rnd_cnst_seed 1017106219537032642877583828875051302543807092889754935647094601236425074047
{
  name: earlgrey
  type: top
  rnd_cnst_seed: 1017106219537032642877583828875051302543807092889754935647094601236425074047
  datawidth: "32"
  power:
  {
    domains:
    [
      Aon
      "0"
    ]
    default: "0"
  }
  clocks:
  {
    hier_paths:
    {
      top: clkmgr_aon_clocks.
      ext: ""
      lpg: clkmgr_aon_cg_en.
    }
    srcs:
    [
      {
        name: main
        aon: no
        freq: "100000000"
        ref: false
      }
      {
        name: io
        aon: no
        freq: "96000000"
        ref: false
      }
      {
        name: usb
        aon: no
        freq: "48000000"
        ref: false
      }
      {
        name: aon
        aon: yes
        freq: "200000"
        ref: true
      }
      {
        name: exp
        aon: no
        freq: "72000000"
        ref: false
      }
      {
        name: exp2
        aon: no
        freq: "60000000"
        ref: false
      }
    ]
    derived_srcs:
    [
      {
        name: io_div2
        aon: no
        freq: "48000000"
        ref: false
        div: "2"
        src: io
      }
      {
        name: io_div4
        aon: no
        freq: "24000000"
        ref: false
        div: "4"
        src: io
      }
      {
        name: main_div2
        aon: no
        freq: "50000000"
        ref: false
        div: "2"
        src: main
      }
      {
        name: main_div10
        aon: no
        freq: "10000000"
        ref: false
        div: "10"
        src: main
      }
      {
        name: usb_div4
        aon: no
        freq: "12000000"
        ref: false
        div: "4"
        src: usb
      }
      {
        name: exp_div2
        aon: no
        freq: "36000000"
        ref: false
        div: "2"
        src: exp
      }
      {
        name: exp_div8
        aon: no
        freq: "9000000"
        ref: false
        div: "8"
        src: exp
      }
      {
        name: exp2_div2
        aon: no
        freq: "30000000"
        ref: false
        div: "2"
        src: exp2
      }
      {
        name: exp2_div6
        aon: no
        freq: "10000000"
        ref: false
        div: "6"
        src: exp2
      }
    ]
    groups:
    [
      {
        name: ast
        src: ext
        sw_cg: no
        unique: no
        clocks:
        {
          clk_main_i: main
          clk_io_i: io
          clk_usb_i: usb
          clk_aon_i: aon
          clk_exp_i: exp
          clk_exp2_i: exp2
        }
      }
      {
        name: powerup
        src: top
        sw_cg: no
        unique: no
        clocks:
        {
          clk_io_div4_powerup: io_div4
          clk_aon_powerup: aon
          clk_main_powerup: main
          clk_io_powerup: io
          clk_usb_powerup: usb
          clk_io_div2_powerup: io_div2
          clk_exp_powerup: exp
          clk_main_div2_powerup: main_div2
          clk_main_div10_powerup: main_div10
          clk_usb_div4_powerup: usb_div4
          clk_exp_div2_powerup: exp_div2
          clk_exp_div8_powerup: exp_div8
          clk_exp2_powerup: exp2
          clk_exp2_div2_powerup: exp2_div2
          clk_exp2_div6_powerup: exp2_div6
        }
      }
      {
        name: trans
        src: top
        sw_cg: hint
        unique: yes
        clocks:
        {
          clk_main_kmac: main
        }
      }
      {
        name: infra
        src: top
        sw_cg: no
        unique: no
        clocks:
        {
          clk_io_div4_infra: io_div4
          clk_main_infra: main
          clk_io_infra: io
        }
      }
      {
        name: secure
        src: top
        sw_cg: no
        unique: no
        clocks:
        {
          clk_io_div4_secure: io_div4
          clk_main_secure: main
        }
      }
      {
        name: peri
        src: top
        sw_cg: yes
        unique: no
        clocks:
        {
          clk_io_div4_peri: io_div4
          clk_io_div2_peri: io_div2
          clk_exp_peri: exp
          clk_exp_div2_peri: exp_div2
          clk_exp_div8_peri: exp_div8
          clk_main_div2_peri: main_div2
          clk_main_div10_peri: main_div10
          clk_usb_div4_peri: usb_div4
          clk_main_peri: main
          clk_usb_peri: usb
          clk_exp2_peri: exp2
          clk_exp2_div2_peri: exp2_div2
          clk_exp2_div6_peri: exp2_div6
          clk_io_peri: io
          clk_aon_peri: aon
        }
      }
      {
        name: timers
        src: top
        sw_cg: no
        unique: no
        clocks:
        {
          clk_io_div4_timers: io_div4
          clk_aon_timers: aon
        }
      }
    ]
  }
  resets:
  {
    hier_paths:
    {
      top: rstmgr_aon_resets.
      ext: ""
      lpg: rstmgr_aon_rst_en.
    }
    nodes:
    [
      {
        name: por_aon
        gen: false
        type: top
        domains:
        [
          "0"
          Aon
        ]
        shadowed: false
        sw: false
        path: rstmgr_aon_resets.rst_por_aon_n
        clock: aon
      }
      {
        name: lc_src
        gen: false
        type: int
        domains: []
        shadowed: false
        sw: false
        path: ""
        clock: io_div4
      }
      {
        name: sys_src
        gen: false
        type: int
        domains: []
        shadowed: false
        sw: false
        path: ""
        clock: io_div4
      }
      {
        name: por
        gen: true
        type: top
        domains:
        [
          Aon
        ]
        shadowed: false
        sw: false
        path: rstmgr_aon_resets.rst_por_n
        parent: por_aon
        clock: main
      }
      {
        name: por_io
        gen: true
        type: top
        domains:
        [
          Aon
        ]
        shadowed: false
        sw: false
        path: rstmgr_aon_resets.rst_por_io_n
        parent: por_aon
        clock: io
      }
      {
        name: por_io_div2
        gen: true
        type: top
        domains:
        [
          Aon
        ]
        shadowed: false
        sw: false
        path: rstmgr_aon_resets.rst_por_io_div2_n
        parent: por_aon
        clock: io_div2
      }
      {
        name: por_io_div4
        gen: true
        type: top
        domains:
        [
          Aon
        ]
        shadowed: false
        sw: false
        path: rstmgr_aon_resets.rst_por_io_div4_n
        parent: por_aon
        clock: io_div4
      }
      {
        name: por_usb
        gen: true
        type: top
        domains:
        [
          Aon
        ]
        shadowed: false
        sw: false
        path: rstmgr_aon_resets.rst_por_usb_n
        parent: por_aon
        clock: usb
      }
      {
        name: por_exp
        gen: true
        type: top
        domains:
        [
          Aon
        ]
        shadowed: false
        sw: false
        path: rstmgr_aon_resets.rst_por_exp_n
        parent: por_aon
        clock: exp
      }
      {
        name: por_main_div2
        gen: true
        type: top
        domains:
        [
          Aon
        ]
        shadowed: false
        sw: false
        path: rstmgr_aon_resets.rst_por_main_div2_n
        parent: por_aon
        clock: main_div2
      }
      {
        name: por_main_div10
        gen: true
        type: top
        domains:
        [
          Aon
        ]
        shadowed: false
        sw: false
        path: rstmgr_aon_resets.rst_por_main_div10_n
        parent: por_aon
        clock: main_div10
      }
      {
        name: por_usb_div4
        gen: true
        type: top
        domains:
        [
          Aon
        ]
        shadowed: false
        sw: false
        path: rstmgr_aon_resets.rst_por_usb_div4_n
        parent: por_aon
        clock: usb_div4
      }
      {
        name: por_exp_div2
        gen: true
        type: top
        domains:
        [
          Aon
        ]
        shadowed: false
        sw: false
        path: rstmgr_aon_resets.rst_por_exp_div2_n
        parent: por_aon
        clock: exp_div2
      }
      {
        name: por_exp_div8
        gen: true
        type: top
        domains:
        [
          Aon
        ]
        shadowed: false
        sw: false
        path: rstmgr_aon_resets.rst_por_exp_div8_n
        parent: por_aon
        clock: exp_div8
      }
      {
        name: por_exp2
        gen: true
        type: top
        domains:
        [
          Aon
        ]
        shadowed: false
        sw: false
        path: rstmgr_aon_resets.rst_por_exp2_n
        parent: por_aon
        clock: exp2
      }
      {
        name: por_exp2_div2
        gen: true
        type: top
        domains:
        [
          Aon
        ]
        shadowed: false
        sw: false
        path: rstmgr_aon_resets.rst_por_exp2_div2_n
        parent: por_aon
        clock: exp2_div2
      }
      {
        name: por_exp2_div6
        gen: true
        type: top
        domains:
        [
          Aon
        ]
        shadowed: false
        sw: false
        path: rstmgr_aon_resets.rst_por_exp2_div6_n
        parent: por_aon
        clock: exp2_div6
      }
      {
        name: lc
        gen: true
        type: top
        domains:
        [
          "0"
          Aon
        ]
        shadowed: true
        sw: false
        path: rstmgr_aon_resets.rst_lc_n
        parent: lc_src
        clock: main
      }
      {
        name: lc_aon
        gen: true
        type: top
        domains:
        [
          Aon
        ]
        shadowed: false
        sw: false
        path: rstmgr_aon_resets.rst_lc_aon_n
        parent: lc_src
        clock: aon
      }
      {
        name: lc_io
        gen: true
        type: top
        domains:
        [
          Aon
          "0"
        ]
        shadowed: false
        sw: false
        path: rstmgr_aon_resets.rst_lc_io_n
        parent: lc_src
        clock: io
      }
      {
        name: lc_io_div2
        gen: true
        type: top
        domains:
        [
          Aon
        ]
        shadowed: false
        sw: false
        path: rstmgr_aon_resets.rst_lc_io_div2_n
        parent: lc_src
        clock: io_div2
      }
      {
        name: lc_io_div4
        gen: true
        type: top
        domains:
        [
          "0"
          Aon
        ]
        shadowed: true
        sw: false
        path: rstmgr_aon_resets.rst_lc_io_div4_n
        parent: lc_src
        clock: io_div4
      }
      {
        name: lc_usb
        gen: true
        type: top
        domains:
        [
          "0"
          Aon
        ]
        shadowed: false
        sw: false
        path: rstmgr_aon_resets.rst_lc_usb_n
        parent: lc_src
        clock: usb
      }
      {
        name: lc_exp
        gen: true
        type: top
        domains:
        [
          "0"
          Aon
        ]
        shadowed: false
        sw: false
        path: rstmgr_aon_resets.rst_lc_exp_n
        parent: lc_src
        clock: exp
      }
      {
        name: lc_main_div2
        gen: true
        type: top
        domains:
        [
          "0"
          Aon
        ]
        shadowed: false
        sw: false
        path: rstmgr_aon_resets.rst_lc_main_div2_n
        parent: lc_src
        clock: main_div2
      }
      {
        name: lc_main_div10
        gen: true
        type: top
        domains:
        [
          "0"
          Aon
        ]
        shadowed: false
        sw: false
        path: rstmgr_aon_resets.rst_lc_main_div10_n
        parent: lc_src
        clock: main_div10
      }
      {
        name: lc_usb_div4
        gen: true
        type: top
        domains:
        [
          "0"
          Aon
        ]
        shadowed: false
        sw: false
        path: rstmgr_aon_resets.rst_lc_usb_div4_n
        parent: lc_src
        clock: usb_div4
      }
      {
        name: lc_exp_div2
        gen: true
        type: top
        domains:
        [
          "0"
          Aon
        ]
        shadowed: false
        sw: false
        path: rstmgr_aon_resets.rst_lc_exp_div2_n
        parent: lc_src
        clock: exp_div2
      }
      {
        name: lc_exp_div8
        gen: true
        type: top
        domains:
        [
          "0"
          Aon
        ]
        shadowed: false
        sw: false
        path: rstmgr_aon_resets.rst_lc_exp_div8_n
        parent: lc_src
        clock: exp_div8
      }
      {
        name: lc_exp2
        gen: true
        type: top
        domains:
        [
          "0"
          Aon
        ]
        shadowed: false
        sw: false
        path: rstmgr_aon_resets.rst_lc_exp2_n
        parent: lc_src
        clock: exp2
      }
      {
        name: lc_exp2_div2
        gen: true
        type: top
        domains:
        [
          "0"
          Aon
        ]
        shadowed: false
        sw: false
        path: rstmgr_aon_resets.rst_lc_exp2_div2_n
        parent: lc_src
        clock: exp2_div2
      }
      {
        name: lc_exp2_div6
        gen: true
        type: top
        domains:
        [
          "0"
          Aon
        ]
        shadowed: false
        sw: false
        path: rstmgr_aon_resets.rst_lc_exp2_div6_n
        parent: lc_src
        clock: exp2_div6
      }
      {
        name: sys
        gen: true
        type: top
        domains:
        [
          "0"
        ]
        shadowed: false
        sw: false
        path: rstmgr_aon_resets.rst_sys_n
        parent: sys_src
        clock: main
      }
      {
        name: sys_io_div4
        gen: true
        type: top
        domains:
        [
          Aon
        ]
        shadowed: false
        sw: false
        path: rstmgr_aon_resets.rst_sys_io_div4_n
        parent: sys_src
        clock: io_div4
      }
      {
        name: spi_device
        gen: true
        type: top
        domains:
        [
          "0"
        ]
        shadowed: false
        sw: true
        path: rstmgr_aon_resets.rst_spi_device_n
        parent: lc_src
        clock: io_div4
      }
      {
        name: spi_host0
        gen: true
        type: top
        domains:
        [
          "0"
        ]
        shadowed: false
        sw: true
        path: rstmgr_aon_resets.rst_spi_host0_n
        parent: lc_src
        clock: io
      }
      {
        name: usb
        gen: true
        type: top
        domains:
        [
          "0"
        ]
        shadowed: false
        sw: true
        path: rstmgr_aon_resets.rst_usb_n
        parent: lc_src
        clock: usb
      }
      {
        name: i2c0
        gen: true
        type: top
        domains:
        [
          "0"
        ]
        shadowed: false
        sw: true
        path: rstmgr_aon_resets.rst_i2c0_n
        parent: lc_src
        clock: io_div4
      }
    ]
  }
  num_cores: "1"
  module:
  [
    {
      name: uart0
      type: uart
      clock_srcs:
      {
        clk_i: io_div4
      }
      clock_group: peri
      reset_connections:
      {
        rst_ni:
        {
          name: lc_io_div4
          domain: "0"
        }
      }
      clock_connections:
      {
        clk_i: clkmgr_aon_clocks.clk_io_div4_peri
      }
      domain:
      [
        "0"
      ]
      param_decl: {}
      param_list: []
      inter_signal_list:
      [
        {
          name: tl
          struct: tl
          package: tlul_pkg
          type: req_rsp
          act: rsp
          width: 1
          inst_name: uart0
          default: ""
          end_idx: -1
          top_signame: uart0_tl
          index: -1
        }
      ]
      base_addrs:
      {
        null: 0x40000000
      }
    }
    {
      name: gpio
      type: gpio
      clock_srcs:
      {
        clk_i: io_div4
      }
      clock_group: peri
      reset_connections:
      {
        rst_ni:
        {
          name: lc_io_div4
          domain: "0"
        }
      }
      param_decl:
      {
        GpioAsyncOn: "1"
      }
      clock_connections:
      {
        clk_i: clkmgr_aon_clocks.clk_io_div4_peri
      }
      domain:
      [
        "0"
      ]
      memory: {}
      param_list:
      [
        {
          name: GpioAsyncOn
          desc: Instantiates 2-flop synchronizers on all GPIO inputs if set to 1.
          type: bit
          default: "1"
          expose: "true"
          name_top: GpioGpioAsyncOn
        }
      ]
      inter_signal_list:
      [
        {
          name: tl
          struct: tl
          package: tlul_pkg
          type: req_rsp
          act: rsp
          width: 1
          inst_name: gpio
          default: ""
          end_idx: -1
          top_signame: gpio_tl
          index: -1
        }
      ]
      base_addrs:
      {
        null: 0x40040000
      }
    }
    {
      name: spi_device
      type: spi_device
      clock_srcs:
      {
        clk_i: io_div4
        scan_clk_i: io_div2
      }
      clock_group: peri
      reset_connections:
      {
        rst_ni:
        {
          name: spi_device
          domain: "0"
        }
      }
      clock_connections:
      {
        clk_i: clkmgr_aon_clocks.clk_io_div4_peri
        scan_clk_i: clkmgr_aon_clocks.clk_io_div2_peri
      }
      domain:
      [
        "0"
      ]
      param_decl: {}
      memory: {}
      param_list:
      [
        {
          name: SramType
          desc: Sram Entries. Word size is 32bit width.
          type: spi_device_pkg::sram_type_e
          default: spi_device_pkg::DefaultSramType
          expose: "true"
          name_top: SpiDeviceSramType
        }
      ]
      inter_signal_list:
      [
        {
          name: ram_cfg
          struct: ram_2p_cfg
          package: prim_ram_2p_pkg
          type: uni
          act: rcv
          width: 1
          inst_name: spi_device
          default: ""
          top_signame: ast_spi_ram_2p_cfg
          index: -1
        }
        {
          name: passthrough
          struct: passthrough
          package: spi_device_pkg
          type: req_rsp
          act: req
          width: 1
          inst_name: spi_device
          default: ""
          end_idx: -1
          top_signame: spi_device_passthrough
          index: -1
        }
        {
          name: mbist_en
          struct: logic
          type: uni
          act: rcv
          width: 1
          inst_name: spi_device
          index: -1
        }
        {
          name: sck_monitor
          struct: logic
          type: uni
          act: req
          width: 1
          inst_name: spi_device
          default: ""
          package: ""
          external: true
          top_signame: sck_monitor
          conn_type: false
          index: -1
        }
        {
          name: tl
          struct: tl
          package: tlul_pkg
          type: req_rsp
          act: rsp
          width: 1
          inst_name: spi_device
          default: ""
          end_idx: -1
          top_signame: spi_device_tl
          index: -1
        }
      ]
      base_addrs:
      {
        null: 0x40050000
      }
    }
    {
      name: ergo_cdc_bridge0
      type: ergo_cdc_bridge
      clock_srcs:
      {
        clk_i: io_div4
        clk_rd_i: exp
      }
      clock_group: peri
      reset_connections:
      {
        rst_ni:
        {
          name: lc_io_div4
          domain: "0"
        }
        rst_rd_ni:
        {
          name: lc_exp
          domain: "0"
        }
      }
      clock_connections:
      {
        clk_i: clkmgr_aon_clocks.clk_io_div4_peri
        clk_rd_i: clkmgr_aon_clocks.clk_exp_peri
      }
      domain:
      [
        "0"
      ]
      param_decl: {}
      param_list: []
      inter_signal_list:
      [
        {
          name: tl
          struct: tl
          package: tlul_pkg
          type: req_rsp
          act: rsp
          width: 1
          inst_name: ergo_cdc_bridge0
          default: ""
          end_idx: -1
          top_signame: ergo_cdc_bridge0_tl
          index: -1
        }
      ]
      base_addrs:
      {
        null: 0x40060000
      }
    }
    {
      name: ergo_cdc_bridge1
      type: ergo_cdc_bridge
      clock_srcs:
      {
        clk_i: io_div4
        clk_rd_i: exp_div2
      }
      clock_group: peri
      reset_connections:
      {
        rst_ni:
        {
          name: lc_io_div4
          domain: "0"
        }
        rst_rd_ni:
        {
          name: lc_exp_div2
          domain: "0"
        }
      }
      clock_connections:
      {
        clk_i: clkmgr_aon_clocks.clk_io_div4_peri
        clk_rd_i: clkmgr_aon_clocks.clk_exp_div2_peri
      }
      domain:
      [
        "0"
      ]
      param_decl: {}
      param_list: []
      inter_signal_list:
      [
        {
          name: tl
          struct: tl
          package: tlul_pkg
          type: req_rsp
          act: rsp
          width: 1
          inst_name: ergo_cdc_bridge1
          default: ""
          end_idx: -1
          top_signame: ergo_cdc_bridge1_tl
          index: -1
        }
      ]
      base_addrs:
      {
        null: 0x40070000
      }
    }
    {
      name: ergo_cdc_bridge2
      type: ergo_cdc_bridge
      clock_srcs:
      {
        clk_i: io_div4
        clk_rd_i: exp_div8
      }
      clock_group: peri
      reset_connections:
      {
        rst_ni:
        {
          name: lc_io_div4
          domain: "0"
        }
        rst_rd_ni:
        {
          name: lc_exp_div8
          domain: "0"
        }
      }
      clock_connections:
      {
        clk_i: clkmgr_aon_clocks.clk_io_div4_peri
        clk_rd_i: clkmgr_aon_clocks.clk_exp_div8_peri
      }
      domain:
      [
        "0"
      ]
      param_decl: {}
      param_list: []
      inter_signal_list:
      [
        {
          name: tl
          struct: tl
          package: tlul_pkg
          type: req_rsp
          act: rsp
          width: 1
          inst_name: ergo_cdc_bridge2
          default: ""
          end_idx: -1
          top_signame: ergo_cdc_bridge2_tl
          index: -1
        }
      ]
      base_addrs:
      {
        null: 0x400B0000
      }
    }
    {
      name: ergo_cdc_bridge3
      type: ergo_cdc_bridge
      clock_srcs:
      {
        clk_i: io_div4
        clk_rd_i: main_div2
      }
      clock_group: peri
      reset_connections:
      {
        rst_ni:
        {
          name: lc_io_div4
          domain: "0"
        }
        rst_rd_ni:
        {
          name: lc_main_div2
          domain: "0"
        }
      }
      clock_connections:
      {
        clk_i: clkmgr_aon_clocks.clk_io_div4_peri
        clk_rd_i: clkmgr_aon_clocks.clk_main_div2_peri
      }
      domain:
      [
        "0"
      ]
      param_decl: {}
      param_list: []
      inter_signal_list:
      [
        {
          name: tl
          struct: tl
          package: tlul_pkg
          type: req_rsp
          act: rsp
          width: 1
          inst_name: ergo_cdc_bridge3
          default: ""
          end_idx: -1
          top_signame: ergo_cdc_bridge3_tl
          index: -1
        }
      ]
      base_addrs:
      {
        null: 0x400C0000
      }
    }
    {
      name: ergo_cdc_bridge4
      type: ergo_cdc_bridge
      clock_srcs:
      {
        clk_i: io_div4
        clk_rd_i: main_div10
      }
      clock_group: peri
      reset_connections:
      {
        rst_ni:
        {
          name: lc_io_div4
          domain: "0"
        }
        rst_rd_ni:
        {
          name: lc_main_div10
          domain: "0"
        }
      }
      clock_connections:
      {
        clk_i: clkmgr_aon_clocks.clk_io_div4_peri
        clk_rd_i: clkmgr_aon_clocks.clk_main_div10_peri
      }
      domain:
      [
        "0"
      ]
      param_decl: {}
      param_list: []
      inter_signal_list:
      [
        {
          name: tl
          struct: tl
          package: tlul_pkg
          type: req_rsp
          act: rsp
          width: 1
          inst_name: ergo_cdc_bridge4
          default: ""
          end_idx: -1
          top_signame: ergo_cdc_bridge4_tl
          index: -1
        }
      ]
      base_addrs:
      {
        null: 0x400D0000
      }
    }
    {
      name: ergo_cdc_bridge5
      type: ergo_cdc_bridge
      clock_srcs:
      {
        clk_i: io_div4
        clk_rd_i: usb_div4
      }
      clock_group: peri
      reset_connections:
      {
        rst_ni:
        {
          name: lc_io_div4
          domain: "0"
        }
        rst_rd_ni:
        {
          name: lc_usb_div4
          domain: "0"
        }
      }
      clock_connections:
      {
        clk_i: clkmgr_aon_clocks.clk_io_div4_peri
        clk_rd_i: clkmgr_aon_clocks.clk_usb_div4_peri
      }
      domain:
      [
        "0"
      ]
      param_decl: {}
      param_list: []
      inter_signal_list:
      [
        {
          name: tl
          struct: tl
          package: tlul_pkg
          type: req_rsp
          act: rsp
          width: 1
          inst_name: ergo_cdc_bridge5
          default: ""
          end_idx: -1
          top_signame: ergo_cdc_bridge5_tl
          index: -1
        }
      ]
      base_addrs:
      {
        null: 0x40110000
      }
    }
    {
      name: ergo_setup_gen0
      type: ergo_setup_gen
      clock_srcs:
      {
        clk_i: io_div4
        clk_gen_i: exp
      }
      clock_group: peri
      reset_connections:
      {
        rst_ni:
        {
          name: lc_io_div4
          domain: "0"
        }
        rst_gen_ni:
        {
          name: lc_exp
          domain: "0"
        }
      }
      clock_connections:
      {
        clk_i: clkmgr_aon_clocks.clk_io_div4_peri
        clk_gen_i: clkmgr_aon_clocks.clk_exp_peri
      }
      domain:
      [
        "0"
      ]
      param_decl: {}
      param_list: []
      inter_signal_list:
      [
        {
          name: tl
          struct: tl
          package: tlul_pkg
          type: req_rsp
          act: rsp
          width: 1
          inst_name: ergo_setup_gen0
          default: ""
          end_idx: -1
          top_signame: ergo_setup_gen0_tl
          index: -1
        }
      ]
      base_addrs:
      {
        null: 0x40120000
      }
    }
    {
      name: ergo_setup_gen1
      type: ergo_setup_gen
      clock_srcs:
      {
        clk_i: io_div4
        clk_gen_i: exp_div2
      }
      clock_group: peri
      reset_connections:
      {
        rst_ni:
        {
          name: lc_io_div4
          domain: "0"
        }
        rst_gen_ni:
        {
          name: lc_exp_div2
          domain: "0"
        }
      }
      clock_connections:
      {
        clk_i: clkmgr_aon_clocks.clk_io_div4_peri
        clk_gen_i: clkmgr_aon_clocks.clk_exp_div2_peri
      }
      domain:
      [
        "0"
      ]
      param_decl: {}
      param_list: []
      inter_signal_list:
      [
        {
          name: tl
          struct: tl
          package: tlul_pkg
          type: req_rsp
          act: rsp
          width: 1
          inst_name: ergo_setup_gen1
          default: ""
          end_idx: -1
          top_signame: ergo_setup_gen1_tl
          index: -1
        }
      ]
      base_addrs:
      {
        null: 0x40160000
      }
    }
    {
      name: ergo_setup_gen2
      type: ergo_setup_gen
      clock_srcs:
      {
        clk_i: io_div4
        clk_gen_i: exp_div8
      }
      clock_group: peri
      reset_connections:
      {
        rst_ni:
        {
          name: lc_io_div4
          domain: "0"
        }
        rst_gen_ni:
        {
          name: lc_exp_div8
          domain: "0"
        }
      }
      clock_connections:
      {
        clk_i: clkmgr_aon_clocks.clk_io_div4_peri
        clk_gen_i: clkmgr_aon_clocks.clk_exp_div8_peri
      }
      domain:
      [
        "0"
      ]
      param_decl: {}
      param_list: []
      inter_signal_list:
      [
        {
          name: tl
          struct: tl
          package: tlul_pkg
          type: req_rsp
          act: rsp
          width: 1
          inst_name: ergo_setup_gen2
          default: ""
          end_idx: -1
          top_signame: ergo_setup_gen2_tl
          index: -1
        }
      ]
      base_addrs:
      {
        null: 0x40170000
      }
    }
    {
      name: ergo_setup_gen3
      type: ergo_setup_gen
      clock_srcs:
      {
        clk_i: io_div4
        clk_gen_i: main_div2
      }
      clock_group: peri
      reset_connections:
      {
        rst_ni:
        {
          name: lc_io_div4
          domain: "0"
        }
        rst_gen_ni:
        {
          name: lc_main_div2
          domain: "0"
        }
      }
      clock_connections:
      {
        clk_i: clkmgr_aon_clocks.clk_io_div4_peri
        clk_gen_i: clkmgr_aon_clocks.clk_main_div2_peri
      }
      domain:
      [
        "0"
      ]
      param_decl: {}
      param_list: []
      inter_signal_list:
      [
        {
          name: tl
          struct: tl
          package: tlul_pkg
          type: req_rsp
          act: rsp
          width: 1
          inst_name: ergo_setup_gen3
          default: ""
          end_idx: -1
          top_signame: ergo_setup_gen3_tl
          index: -1
        }
      ]
      base_addrs:
      {
        null: 0x40180000
      }
    }
    {
      name: ergo_setup_gen4
      type: ergo_setup_gen
      clock_srcs:
      {
        clk_i: io_div4
        clk_gen_i: main_div10
      }
      clock_group: peri
      reset_connections:
      {
        rst_ni:
        {
          name: lc_io_div4
          domain: "0"
        }
        rst_gen_ni:
        {
          name: lc_main_div10
          domain: "0"
        }
      }
      clock_connections:
      {
        clk_i: clkmgr_aon_clocks.clk_io_div4_peri
        clk_gen_i: clkmgr_aon_clocks.clk_main_div10_peri
      }
      domain:
      [
        "0"
      ]
      param_decl: {}
      param_list: []
      inter_signal_list:
      [
        {
          name: tl
          struct: tl
          package: tlul_pkg
          type: req_rsp
          act: rsp
          width: 1
          inst_name: ergo_setup_gen4
          default: ""
          end_idx: -1
          top_signame: ergo_setup_gen4_tl
          index: -1
        }
      ]
      base_addrs:
      {
        null: 0x40190000
      }
    }
    {
      name: ergo_setup_gen5
      type: ergo_setup_gen
      clock_srcs:
      {
        clk_i: io_div4
        clk_gen_i: usb_div4
      }
      clock_group: peri
      reset_connections:
      {
        rst_ni:
        {
          name: lc_io_div4
          domain: "0"
        }
        rst_gen_ni:
        {
          name: lc_usb_div4
          domain: "0"
        }
      }
      clock_connections:
      {
        clk_i: clkmgr_aon_clocks.clk_io_div4_peri
        clk_gen_i: clkmgr_aon_clocks.clk_usb_div4_peri
      }
      domain:
      [
        "0"
      ]
      param_decl: {}
      param_list: []
      inter_signal_list:
      [
        {
          name: tl
          struct: tl
          package: tlul_pkg
          type: req_rsp
          act: rsp
          width: 1
          inst_name: ergo_setup_gen5
          default: ""
          end_idx: -1
          top_signame: ergo_setup_gen5_tl
          index: -1
        }
      ]
      base_addrs:
      {
        null: 0x401A0000
      }
    }
    {
      name: ergo_hold_gen0
      type: ergo_hold_gen
      clock_srcs:
      {
        clk_i: io_div4
        clk_a_i: exp
        clk_b_i: exp_div2
      }
      clock_group: peri
      reset_connections:
      {
        rst_ni:
        {
          name: lc_io_div4
          domain: "0"
        }
        rst_a_ni:
        {
          name: lc_exp
          domain: "0"
        }
        rst_b_ni:
        {
          name: lc_exp_div2
          domain: "0"
        }
      }
      clock_connections:
      {
        clk_i: clkmgr_aon_clocks.clk_io_div4_peri
        clk_a_i: clkmgr_aon_clocks.clk_exp_peri
        clk_b_i: clkmgr_aon_clocks.clk_exp_div2_peri
      }
      domain:
      [
        "0"
      ]
      param_decl: {}
      param_list: []
      inter_signal_list:
      [
        {
          name: tl
          struct: tl
          package: tlul_pkg
          type: req_rsp
          act: rsp
          width: 1
          inst_name: ergo_hold_gen0
          default: ""
          end_idx: -1
          top_signame: ergo_hold_gen0_tl
          index: -1
        }
      ]
      base_addrs:
      {
        null: 0x401B0000
      }
    }
    {
      name: ergo_hold_gen1
      type: ergo_hold_gen
      clock_srcs:
      {
        clk_i: io_div4
        clk_a_i: exp
        clk_b_i: exp_div8
      }
      clock_group: peri
      reset_connections:
      {
        rst_ni:
        {
          name: lc_io_div4
          domain: "0"
        }
        rst_a_ni:
        {
          name: lc_exp
          domain: "0"
        }
        rst_b_ni:
        {
          name: lc_exp_div8
          domain: "0"
        }
      }
      clock_connections:
      {
        clk_i: clkmgr_aon_clocks.clk_io_div4_peri
        clk_a_i: clkmgr_aon_clocks.clk_exp_peri
        clk_b_i: clkmgr_aon_clocks.clk_exp_div8_peri
      }
      domain:
      [
        "0"
      ]
      param_decl: {}
      param_list: []
      inter_signal_list:
      [
        {
          name: tl
          struct: tl
          package: tlul_pkg
          type: req_rsp
          act: rsp
          width: 1
          inst_name: ergo_hold_gen1
          default: ""
          end_idx: -1
          top_signame: ergo_hold_gen1_tl
          index: -1
        }
      ]
      base_addrs:
      {
        null: 0x401C0000
      }
    }
    {
      name: ergo_hold_gen2
      type: ergo_hold_gen
      clock_srcs:
      {
        clk_i: io_div4
        clk_a_i: main
        clk_b_i: main_div2
      }
      clock_group: peri
      reset_connections:
      {
        rst_ni:
        {
          name: lc_io_div4
          domain: "0"
        }
        rst_a_ni:
        {
          name: lc
          domain: "0"
        }
        rst_b_ni:
        {
          name: lc_main_div2
          domain: "0"
        }
      }
      clock_connections:
      {
        clk_i: clkmgr_aon_clocks.clk_io_div4_peri
        clk_a_i: clkmgr_aon_clocks.clk_main_peri
        clk_b_i: clkmgr_aon_clocks.clk_main_div2_peri
      }
      domain:
      [
        "0"
      ]
      param_decl: {}
      param_list: []
      inter_signal_list:
      [
        {
          name: tl
          struct: tl
          package: tlul_pkg
          type: req_rsp
          act: rsp
          width: 1
          inst_name: ergo_hold_gen2
          default: ""
          end_idx: -1
          top_signame: ergo_hold_gen2_tl
          index: -1
        }
      ]
      base_addrs:
      {
        null: 0x401D0000
      }
    }
    {
      name: ergo_hold_gen3
      type: ergo_hold_gen
      clock_srcs:
      {
        clk_i: io_div4
        clk_a_i: main
        clk_b_i: main_div10
      }
      clock_group: peri
      reset_connections:
      {
        rst_ni:
        {
          name: lc_io_div4
          domain: "0"
        }
        rst_a_ni:
        {
          name: lc
          domain: "0"
        }
        rst_b_ni:
        {
          name: lc_main_div10
          domain: "0"
        }
      }
      clock_connections:
      {
        clk_i: clkmgr_aon_clocks.clk_io_div4_peri
        clk_a_i: clkmgr_aon_clocks.clk_main_peri
        clk_b_i: clkmgr_aon_clocks.clk_main_div10_peri
      }
      domain:
      [
        "0"
      ]
      param_decl: {}
      param_list: []
      inter_signal_list:
      [
        {
          name: tl
          struct: tl
          package: tlul_pkg
          type: req_rsp
          act: rsp
          width: 1
          inst_name: ergo_hold_gen3
          default: ""
          end_idx: -1
          top_signame: ergo_hold_gen3_tl
          index: -1
        }
      ]
      base_addrs:
      {
        null: 0x401E0000
      }
    }
    {
      name: ergo_hold_gen4
      type: ergo_hold_gen
      clock_srcs:
      {
        clk_i: io_div4
        clk_a_i: usb
        clk_b_i: usb_div4
      }
      clock_group: peri
      reset_connections:
      {
        rst_ni:
        {
          name: lc_io_div4
          domain: "0"
        }
        rst_a_ni:
        {
          name: lc_usb
          domain: "0"
        }
        rst_b_ni:
        {
          name: lc_usb_div4
          domain: "0"
        }
      }
      clock_connections:
      {
        clk_i: clkmgr_aon_clocks.clk_io_div4_peri
        clk_a_i: clkmgr_aon_clocks.clk_usb_peri
        clk_b_i: clkmgr_aon_clocks.clk_usb_div4_peri
      }
      domain:
      [
        "0"
      ]
      param_decl: {}
      param_list: []
      inter_signal_list:
      [
        {
          name: tl
          struct: tl
          package: tlul_pkg
          type: req_rsp
          act: rsp
          width: 1
          inst_name: ergo_hold_gen4
          default: ""
          end_idx: -1
          top_signame: ergo_hold_gen4_tl
          index: -1
        }
      ]
      base_addrs:
      {
        null: 0x401F0000
      }
    }
    {
      name: ergo_cdc_hazard_gen0
      type: ergo_cdc_hazard_gen
      clock_srcs:
      {
        clk_i: io_div4
        clk_a_i: exp
        clk_b_i: exp_div2
      }
      clock_group: peri
      reset_connections:
      {
        rst_ni:
        {
          name: lc_io_div4
          domain: "0"
        }
        rst_a_ni:
        {
          name: lc_exp
          domain: "0"
        }
        rst_b_ni:
        {
          name: lc_exp_div2
          domain: "0"
        }
      }
      clock_connections:
      {
        clk_i: clkmgr_aon_clocks.clk_io_div4_peri
        clk_a_i: clkmgr_aon_clocks.clk_exp_peri
        clk_b_i: clkmgr_aon_clocks.clk_exp_div2_peri
      }
      domain:
      [
        "0"
      ]
      param_decl: {}
      param_list: []
      inter_signal_list:
      [
        {
          name: tl
          struct: tl
          package: tlul_pkg
          type: req_rsp
          act: rsp
          width: 1
          inst_name: ergo_cdc_hazard_gen0
          default: ""
          end_idx: -1
          top_signame: ergo_cdc_hazard_gen0_tl
          index: -1
        }
      ]
      base_addrs:
      {
        null: 0x40200000
      }
    }
    {
      name: ergo_cdc_hazard_gen1
      type: ergo_cdc_hazard_gen
      clock_srcs:
      {
        clk_i: io_div4
        clk_a_i: exp
        clk_b_i: exp_div8
      }
      clock_group: peri
      reset_connections:
      {
        rst_ni:
        {
          name: lc_io_div4
          domain: "0"
        }
        rst_a_ni:
        {
          name: lc_exp
          domain: "0"
        }
        rst_b_ni:
        {
          name: lc_exp_div8
          domain: "0"
        }
      }
      clock_connections:
      {
        clk_i: clkmgr_aon_clocks.clk_io_div4_peri
        clk_a_i: clkmgr_aon_clocks.clk_exp_peri
        clk_b_i: clkmgr_aon_clocks.clk_exp_div8_peri
      }
      domain:
      [
        "0"
      ]
      param_decl: {}
      param_list: []
      inter_signal_list:
      [
        {
          name: tl
          struct: tl
          package: tlul_pkg
          type: req_rsp
          act: rsp
          width: 1
          inst_name: ergo_cdc_hazard_gen1
          default: ""
          end_idx: -1
          top_signame: ergo_cdc_hazard_gen1_tl
          index: -1
        }
      ]
      base_addrs:
      {
        null: 0x40210000
      }
    }
    {
      name: ergo_cdc_hazard_gen2
      type: ergo_cdc_hazard_gen
      clock_srcs:
      {
        clk_i: io_div4
        clk_a_i: main
        clk_b_i: main_div2
      }
      clock_group: peri
      reset_connections:
      {
        rst_ni:
        {
          name: lc_io_div4
          domain: "0"
        }
        rst_a_ni:
        {
          name: lc
          domain: "0"
        }
        rst_b_ni:
        {
          name: lc_main_div2
          domain: "0"
        }
      }
      clock_connections:
      {
        clk_i: clkmgr_aon_clocks.clk_io_div4_peri
        clk_a_i: clkmgr_aon_clocks.clk_main_peri
        clk_b_i: clkmgr_aon_clocks.clk_main_div2_peri
      }
      domain:
      [
        "0"
      ]
      param_decl: {}
      param_list: []
      inter_signal_list:
      [
        {
          name: tl
          struct: tl
          package: tlul_pkg
          type: req_rsp
          act: rsp
          width: 1
          inst_name: ergo_cdc_hazard_gen2
          default: ""
          end_idx: -1
          top_signame: ergo_cdc_hazard_gen2_tl
          index: -1
        }
      ]
      base_addrs:
      {
        null: 0x40220000
      }
    }
    {
      name: ergo_cdc_hazard_gen3
      type: ergo_cdc_hazard_gen
      clock_srcs:
      {
        clk_i: io_div4
        clk_a_i: main
        clk_b_i: main_div10
      }
      clock_group: peri
      reset_connections:
      {
        rst_ni:
        {
          name: lc_io_div4
          domain: "0"
        }
        rst_a_ni:
        {
          name: lc
          domain: "0"
        }
        rst_b_ni:
        {
          name: lc_main_div10
          domain: "0"
        }
      }
      clock_connections:
      {
        clk_i: clkmgr_aon_clocks.clk_io_div4_peri
        clk_a_i: clkmgr_aon_clocks.clk_main_peri
        clk_b_i: clkmgr_aon_clocks.clk_main_div10_peri
      }
      domain:
      [
        "0"
      ]
      param_decl: {}
      param_list: []
      inter_signal_list:
      [
        {
          name: tl
          struct: tl
          package: tlul_pkg
          type: req_rsp
          act: rsp
          width: 1
          inst_name: ergo_cdc_hazard_gen3
          default: ""
          end_idx: -1
          top_signame: ergo_cdc_hazard_gen3_tl
          index: -1
        }
      ]
      base_addrs:
      {
        null: 0x40230000
      }
    }
    {
      name: ergo_cdc_hazard_gen4
      type: ergo_cdc_hazard_gen
      clock_srcs:
      {
        clk_i: io_div4
        clk_a_i: usb
        clk_b_i: usb_div4
      }
      clock_group: peri
      reset_connections:
      {
        rst_ni:
        {
          name: lc_io_div4
          domain: "0"
        }
        rst_a_ni:
        {
          name: lc_usb
          domain: "0"
        }
        rst_b_ni:
        {
          name: lc_usb_div4
          domain: "0"
        }
      }
      clock_connections:
      {
        clk_i: clkmgr_aon_clocks.clk_io_div4_peri
        clk_a_i: clkmgr_aon_clocks.clk_usb_peri
        clk_b_i: clkmgr_aon_clocks.clk_usb_div4_peri
      }
      domain:
      [
        "0"
      ]
      param_decl: {}
      param_list: []
      inter_signal_list:
      [
        {
          name: tl
          struct: tl
          package: tlul_pkg
          type: req_rsp
          act: rsp
          width: 1
          inst_name: ergo_cdc_hazard_gen4
          default: ""
          end_idx: -1
          top_signame: ergo_cdc_hazard_gen4_tl
          index: -1
        }
      ]
      base_addrs:
      {
        null: 0x40240000
      }
    }
    {
      name: ergo_cdc_bridge6
      type: ergo_cdc_bridge
      clock_srcs:
      {
        clk_i: io_div4
        clk_rd_i: exp2
      }
      clock_group: peri
      reset_connections:
      {
        rst_ni:
        {
          name: lc_io_div4
          domain: "0"
        }
        rst_rd_ni:
        {
          name: lc_exp2
          domain: "0"
        }
      }
      clock_connections:
      {
        clk_i: clkmgr_aon_clocks.clk_io_div4_peri
        clk_rd_i: clkmgr_aon_clocks.clk_exp2_peri
      }
      domain:
      [
        "0"
      ]
      param_decl: {}
      param_list: []
      inter_signal_list:
      [
        {
          name: tl
          struct: tl
          package: tlul_pkg
          type: req_rsp
          act: rsp
          width: 1
          inst_name: ergo_cdc_bridge6
          default: ""
          end_idx: -1
          top_signame: ergo_cdc_bridge6_tl
          index: -1
        }
      ]
      base_addrs:
      {
        null: 0x40250000
      }
    }
    {
      name: ergo_cdc_bridge7
      type: ergo_cdc_bridge
      clock_srcs:
      {
        clk_i: io_div4
        clk_rd_i: exp2_div2
      }
      clock_group: peri
      reset_connections:
      {
        rst_ni:
        {
          name: lc_io_div4
          domain: "0"
        }
        rst_rd_ni:
        {
          name: lc_exp2_div2
          domain: "0"
        }
      }
      clock_connections:
      {
        clk_i: clkmgr_aon_clocks.clk_io_div4_peri
        clk_rd_i: clkmgr_aon_clocks.clk_exp2_div2_peri
      }
      domain:
      [
        "0"
      ]
      param_decl: {}
      param_list: []
      inter_signal_list:
      [
        {
          name: tl
          struct: tl
          package: tlul_pkg
          type: req_rsp
          act: rsp
          width: 1
          inst_name: ergo_cdc_bridge7
          default: ""
          end_idx: -1
          top_signame: ergo_cdc_bridge7_tl
          index: -1
        }
      ]
      base_addrs:
      {
        null: 0x40260000
      }
    }
    {
      name: ergo_cdc_bridge8
      type: ergo_cdc_bridge
      clock_srcs:
      {
        clk_i: io_div4
        clk_rd_i: exp2_div6
      }
      clock_group: peri
      reset_connections:
      {
        rst_ni:
        {
          name: lc_io_div4
          domain: "0"
        }
        rst_rd_ni:
        {
          name: lc_exp2_div6
          domain: "0"
        }
      }
      clock_connections:
      {
        clk_i: clkmgr_aon_clocks.clk_io_div4_peri
        clk_rd_i: clkmgr_aon_clocks.clk_exp2_div6_peri
      }
      domain:
      [
        "0"
      ]
      param_decl: {}
      param_list: []
      inter_signal_list:
      [
        {
          name: tl
          struct: tl
          package: tlul_pkg
          type: req_rsp
          act: rsp
          width: 1
          inst_name: ergo_cdc_bridge8
          default: ""
          end_idx: -1
          top_signame: ergo_cdc_bridge8_tl
          index: -1
        }
      ]
      base_addrs:
      {
        null: 0x40270000
      }
    }
    {
      name: ergo_setup_gen6
      type: ergo_setup_gen
      clock_srcs:
      {
        clk_i: io_div4
        clk_gen_i: exp2
      }
      clock_group: peri
      reset_connections:
      {
        rst_ni:
        {
          name: lc_io_div4
          domain: "0"
        }
        rst_gen_ni:
        {
          name: lc_exp2
          domain: "0"
        }
      }
      clock_connections:
      {
        clk_i: clkmgr_aon_clocks.clk_io_div4_peri
        clk_gen_i: clkmgr_aon_clocks.clk_exp2_peri
      }
      domain:
      [
        "0"
      ]
      param_decl: {}
      param_list: []
      inter_signal_list:
      [
        {
          name: tl
          struct: tl
          package: tlul_pkg
          type: req_rsp
          act: rsp
          width: 1
          inst_name: ergo_setup_gen6
          default: ""
          end_idx: -1
          top_signame: ergo_setup_gen6_tl
          index: -1
        }
      ]
      base_addrs:
      {
        null: 0x40280000
      }
    }
    {
      name: ergo_setup_gen7
      type: ergo_setup_gen
      clock_srcs:
      {
        clk_i: io_div4
        clk_gen_i: exp2_div2
      }
      clock_group: peri
      reset_connections:
      {
        rst_ni:
        {
          name: lc_io_div4
          domain: "0"
        }
        rst_gen_ni:
        {
          name: lc_exp2_div2
          domain: "0"
        }
      }
      clock_connections:
      {
        clk_i: clkmgr_aon_clocks.clk_io_div4_peri
        clk_gen_i: clkmgr_aon_clocks.clk_exp2_div2_peri
      }
      domain:
      [
        "0"
      ]
      param_decl: {}
      param_list: []
      inter_signal_list:
      [
        {
          name: tl
          struct: tl
          package: tlul_pkg
          type: req_rsp
          act: rsp
          width: 1
          inst_name: ergo_setup_gen7
          default: ""
          end_idx: -1
          top_signame: ergo_setup_gen7_tl
          index: -1
        }
      ]
      base_addrs:
      {
        null: 0x40290000
      }
    }
    {
      name: ergo_setup_gen8
      type: ergo_setup_gen
      clock_srcs:
      {
        clk_i: io_div4
        clk_gen_i: exp2_div6
      }
      clock_group: peri
      reset_connections:
      {
        rst_ni:
        {
          name: lc_io_div4
          domain: "0"
        }
        rst_gen_ni:
        {
          name: lc_exp2_div6
          domain: "0"
        }
      }
      clock_connections:
      {
        clk_i: clkmgr_aon_clocks.clk_io_div4_peri
        clk_gen_i: clkmgr_aon_clocks.clk_exp2_div6_peri
      }
      domain:
      [
        "0"
      ]
      param_decl: {}
      param_list: []
      inter_signal_list:
      [
        {
          name: tl
          struct: tl
          package: tlul_pkg
          type: req_rsp
          act: rsp
          width: 1
          inst_name: ergo_setup_gen8
          default: ""
          end_idx: -1
          top_signame: ergo_setup_gen8_tl
          index: -1
        }
      ]
      base_addrs:
      {
        null: 0x402A0000
      }
    }
    {
      name: ergo_hold_gen5
      type: ergo_hold_gen
      clock_srcs:
      {
        clk_i: io_div4
        clk_a_i: exp2
        clk_b_i: exp2_div2
      }
      clock_group: peri
      reset_connections:
      {
        rst_ni:
        {
          name: lc_io_div4
          domain: "0"
        }
        rst_a_ni:
        {
          name: lc_exp2
          domain: "0"
        }
        rst_b_ni:
        {
          name: lc_exp2_div2
          domain: "0"
        }
      }
      clock_connections:
      {
        clk_i: clkmgr_aon_clocks.clk_io_div4_peri
        clk_a_i: clkmgr_aon_clocks.clk_exp2_peri
        clk_b_i: clkmgr_aon_clocks.clk_exp2_div2_peri
      }
      domain:
      [
        "0"
      ]
      param_decl: {}
      param_list: []
      inter_signal_list:
      [
        {
          name: tl
          struct: tl
          package: tlul_pkg
          type: req_rsp
          act: rsp
          width: 1
          inst_name: ergo_hold_gen5
          default: ""
          end_idx: -1
          top_signame: ergo_hold_gen5_tl
          index: -1
        }
      ]
      base_addrs:
      {
        null: 0x402B0000
      }
    }
    {
      name: ergo_hold_gen6
      type: ergo_hold_gen
      clock_srcs:
      {
        clk_i: io_div4
        clk_a_i: exp2
        clk_b_i: exp2_div6
      }
      clock_group: peri
      reset_connections:
      {
        rst_ni:
        {
          name: lc_io_div4
          domain: "0"
        }
        rst_a_ni:
        {
          name: lc_exp2
          domain: "0"
        }
        rst_b_ni:
        {
          name: lc_exp2_div6
          domain: "0"
        }
      }
      clock_connections:
      {
        clk_i: clkmgr_aon_clocks.clk_io_div4_peri
        clk_a_i: clkmgr_aon_clocks.clk_exp2_peri
        clk_b_i: clkmgr_aon_clocks.clk_exp2_div6_peri
      }
      domain:
      [
        "0"
      ]
      param_decl: {}
      param_list: []
      inter_signal_list:
      [
        {
          name: tl
          struct: tl
          package: tlul_pkg
          type: req_rsp
          act: rsp
          width: 1
          inst_name: ergo_hold_gen6
          default: ""
          end_idx: -1
          top_signame: ergo_hold_gen6_tl
          index: -1
        }
      ]
      base_addrs:
      {
        null: 0x402C0000
      }
    }
    {
      name: ergo_cdc_hazard_gen5
      type: ergo_cdc_hazard_gen
      clock_srcs:
      {
        clk_i: io_div4
        clk_a_i: exp2
        clk_b_i: exp2_div2
      }
      clock_group: peri
      reset_connections:
      {
        rst_ni:
        {
          name: lc_io_div4
          domain: "0"
        }
        rst_a_ni:
        {
          name: lc_exp2
          domain: "0"
        }
        rst_b_ni:
        {
          name: lc_exp2_div2
          domain: "0"
        }
      }
      clock_connections:
      {
        clk_i: clkmgr_aon_clocks.clk_io_div4_peri
        clk_a_i: clkmgr_aon_clocks.clk_exp2_peri
        clk_b_i: clkmgr_aon_clocks.clk_exp2_div2_peri
      }
      domain:
      [
        "0"
      ]
      param_decl: {}
      param_list: []
      inter_signal_list:
      [
        {
          name: tl
          struct: tl
          package: tlul_pkg
          type: req_rsp
          act: rsp
          width: 1
          inst_name: ergo_cdc_hazard_gen5
          default: ""
          end_idx: -1
          top_signame: ergo_cdc_hazard_gen5_tl
          index: -1
        }
      ]
      base_addrs:
      {
        null: 0x402D0000
      }
    }
    {
      name: ergo_cdc_hazard_gen6
      type: ergo_cdc_hazard_gen
      clock_srcs:
      {
        clk_i: io_div4
        clk_a_i: exp2
        clk_b_i: exp2_div6
      }
      clock_group: peri
      reset_connections:
      {
        rst_ni:
        {
          name: lc_io_div4
          domain: "0"
        }
        rst_a_ni:
        {
          name: lc_exp2
          domain: "0"
        }
        rst_b_ni:
        {
          name: lc_exp2_div6
          domain: "0"
        }
      }
      clock_connections:
      {
        clk_i: clkmgr_aon_clocks.clk_io_div4_peri
        clk_a_i: clkmgr_aon_clocks.clk_exp2_peri
        clk_b_i: clkmgr_aon_clocks.clk_exp2_div6_peri
      }
      domain:
      [
        "0"
      ]
      param_decl: {}
      param_list: []
      inter_signal_list:
      [
        {
          name: tl
          struct: tl
          package: tlul_pkg
          type: req_rsp
          act: rsp
          width: 1
          inst_name: ergo_cdc_hazard_gen6
          default: ""
          end_idx: -1
          top_signame: ergo_cdc_hazard_gen6_tl
          index: -1
        }
      ]
      base_addrs:
      {
        null: 0x402E0000
      }
    }
    {
      name: i2c0
      type: i2c
      clock_srcs:
      {
        clk_i: io_div4
      }
      clock_group: peri
      reset_connections:
      {
        rst_ni:
        {
          name: i2c0
          domain: "0"
        }
      }
      clock_connections:
      {
        clk_i: clkmgr_aon_clocks.clk_io_div4_peri
      }
      domain:
      [
        "0"
      ]
      param_decl: {}
      memory: {}
      param_list:
      [
        {
          name: InputDelayCycles
          desc:
            '''
            Maximum number of cycles of propagation delay between a change on the cio_scl_en_o or cio_sda_en_o pins and sensing the new values on the corresponding input pins, not including the rise/fall times.
            For the purposes of this calculation, an input delay of 0 cycles means an output pin changing at the beginning of clock edge N will be sampled and observed on the input pins at clock edge N+1.
            '''
          type: int
          default: "0"
          expose: "true"
          name_top: I2c0InputDelayCycles
        }
      ]
      inter_signal_list:
      [
        {
          name: ram_cfg
          struct: ram_1p_cfg
          package: prim_ram_1p_pkg
          type: uni
          act: rcv
          width: 1
          inst_name: i2c0
          default: ""
          top_signame: ast_ram_1p_cfg
          index: -1
        }
        {
          name: tl
          struct: tl
          package: tlul_pkg
          type: req_rsp
          act: rsp
          width: 1
          inst_name: i2c0
          default: ""
          end_idx: -1
          top_signame: i2c0_tl
          index: -1
        }
      ]
      base_addrs:
      {
        null: 0x40080000
      }
    }
    {
      name: rv_timer
      type: rv_timer
      clock_srcs:
      {
        clk_i: io_div4
      }
      clock_group: timers
      reset_connections:
      {
        rst_ni:
        {
          name: lc_io_div4
          domain: "0"
        }
      }
      clock_connections:
      {
        clk_i: clkmgr_aon_clocks.clk_io_div4_timers
      }
      domain:
      [
        "0"
      ]
      param_decl: {}
      param_list: []
      inter_signal_list:
      [
        {
          name: tl
          struct: tl
          package: tlul_pkg
          type: req_rsp
          act: rsp
          width: 1
          inst_name: rv_timer
          default: ""
          end_idx: -1
          top_signame: rv_timer_tl
          index: -1
        }
      ]
      base_addrs:
      {
        null: 0x40100000
      }
    }
    {
      name: kmac
      type: kmac
      param_decl:
      {
        EnMasking: "1"
      }
      clock_srcs:
      {
        clk_i: main
        clk_edn_i: main
      }
      clock_group: trans
      reset_connections:
      {
        rst_ni:
        {
          name: lc
          domain: "0"
        }
        rst_edn_ni:
        {
          name: lc
          domain: "0"
        }
      }
      clock_connections:
      {
        clk_i: clkmgr_aon_clocks.clk_main_kmac
        clk_edn_i: clkmgr_aon_clocks.clk_main_kmac
      }
      domain:
      [
        "0"
      ]
      memory: {}
      param_list:
      [
        {
          name: EnMasking
          desc: Disable(0) or enable(1) first-order masking of Keccak round.
          type: bit
          default: "1"
          expose: "true"
          name_top: KmacEnMasking
        }
        {
          name: SwKeyMasked
          desc:
            '''
            Disable(0) or enable(1) software key masking in case masking is disabled (EnMasking == 0).
            If masking is enabled, this parameter has no effect.
            Mainly useful for software interface compatibility between the masked and unmasked design.
            Mostly relevant for SCA measurements.
            '''
          type: bit
          default: "0"
          expose: "true"
          name_top: KmacSwKeyMasked
        }
        {
          name: SecCmdDelay
          desc:
            '''
            Command delay, useful for SCA measurements only.
            A value of e.g. 40 allows the processor to go into sleep before KMAC starts operation.
            If a value greater than 0 is chosen, software can pass two commands in series.
            The second command is buffered internally and will be presented to the hardware SecCmdDelay number of cycles after the first one.
            '''
          type: int
          default: "0"
          expose: "true"
          name_top: SecKmacCmdDelay
        }
        {
          name: SecIdleAcceptSwMsg
          desc:
            '''
            If enabled (1), software writes to the message FIFO before having received a START command are not ignored.
            Disabled (0) by default.
            Useful for SCA measurements only.
            '''
          type: bit
          default: "0"
          expose: "true"
          name_top: SecKmacIdleAcceptSwMsg
        }
        {
          name: RndCnstLfsrSeed
          desc: Compile-time random data for PRNG default seed
          type: kmac_pkg::lfsr_seed_t
          randcount: 288
          randtype: data
          name_top: RndCnstKmacLfsrSeed
          default: 0xc8a8cc102f0bdb35e18d565d3e4205ef9ed28a1f4c6dc8cf094bcd1b4b6de9ff2511d585
          randwidth: 288
        }
        {
          name: RndCnstLfsrPerm
          desc: Compile-time random permutation for PRNG output
          type: kmac_pkg::lfsr_perm_t
          randcount: 800
          randtype: perm
          name_top: RndCnstKmacLfsrPerm
          default: 0x3924835666b114d9129e61c9a212957a4091aa915b03231d29029aa4c6e24ce857b1ac6946d4387eb7655be2686bad8bec245984484164c65c7a709c7ce04612aa2225092e2741e14b7c1b27c265781d4fdc4c22dbb98360f97d9867204cfe780b33c42aa9c358ed34a89ad134c5c4e6416cc8bc8009d2ecac073bf02e30d5c902a65d9a80c0d905e8fbfd5746d969daaf7beb1ab0e81397a00e3e296703e8101699c3ddc12f8113a4717c5fc834fc88ae797ddb30a8241b146da0f2a6c24b56d555b89d5fa7e15b99632945e6a4a5690e9b2561a5f93c9eae34dc89c2a4c2b46e662eb98db573d121825c48c3d60e8e0788c898e266d92219d223dcb1feeaa0df718a548fda65e5d43e2a1c014eb0d008a2ed948a1ae18f4adf568e9a145030cd0d8f5468960e5693a975ee805862140d3ccae4429db56a5170c984c69a31daab97cbf4819fdbe358e37970167c18b49bb75ad985c83bde6026dbc4b1427f4199c66e669e1461e73b8cc190bf4f6de8a40eaec316f5b034177be902c388b3b1d05a578722ca2525a1b1944f856118fb3da41199d1bd200469142bcef07f0dc1f18310e06d273474b85a9a96095248526a9140575f43ae8778c8033cff830bca00f582ddf28a6c03ea3140df24d6f94c39471d88f2cd4ba3a4c8224817b2922008eb7b90780be6b1dd2f32ec5a64f94d9d7bbafe30706108983521c11c909bda193d80582ad8b6b49284112d54566789a8fd26427b071d5420a6de190221bb7053926169de81af52a160048184f8b89d0e25e50e690198b6e8877ed418bd725113002d38339dd57e07372b91656119ed601dafa5ed4258ab69c1443317b3212bbd04031563958859539b856eaad89aa17f12a21c309ebd61147dab454cd9370b52258791856feb21f461c091ea19eaa4ea929892084aca2445b6b1bb3a087347b3c8db081cea61fe58a2b1e4164224e3a8a034f1e3683c5a1c9be59e2dca8515c57543b9090a151057e5a01970f58e2aafd352e8d10681c789ca52c574671c0adcc0e9b3302332c23110195aea1e444e6766841271ac257064f03c54703d1c3854918c13b91913362b3afa90209ff91c430dcbb37b047a1c01230570a881e86f17d757718a6302c7ae370fd0995ed75ccb90b401bcce168a35af2796654f6e639676e077a3617a2451d8d39e452aaa0a5875235b19f5515328d016e80d2c9562b500a3865ca34a167ad99114863a527ba2c2980ef0b2e5b1dad12ca021554a99e7e3496bba58e5c5a4b1a6d2f524b20b6055b2642d3826c77d84c04b11c428a1c9815d0682c6d071a623752543ee5bdb161d2c025cb53c0a731a1887e9f459f28b0289645dc49535262349ecf3288e3b6347c117094d7c7c8a42dedbc5d32d07c815224067c1ae1d
          randwidth: 8000
        }
        {
          name: RndCnstBufferLfsrSeed
          desc: Compile-time random data for PRNG buffer default seed
          type: kmac_pkg::buffer_lfsr_seed_t
          randcount: 800
          randtype: data
          name_top: RndCnstKmacBufferLfsrSeed
          default: 0xe364b0dac5469568e661498fd89197ccae8ea08ff43efc2bfb1c6ab5cc63e6f4741e80f777cb7fc05041a1b896350c9636d6814d23e2f5ff1275ef19959aaa8b6a004d5574984ded1cc79bd6787d6663aa5e622682a6525e083ccddbd2a1b008057c22c
          randwidth: 800
        }
        {
          name: RndCnstMsgPerm
          desc: Compile-time random permutation for LFSR Message output
          type: kmac_pkg::msg_perm_t
          randcount: 64
          randtype: perm
          name_top: RndCnstKmacMsgPerm
          default: 0x2d72bb8d57b898272fdbdc65486afc1dfa96003b9192ca3710c174fa077f6f23b0609e7364140850f37a6ada619f54e2
          randwidth: 384
        }
      ]
      inter_signal_list:
      [
        {
          name: keymgr_key
          struct: hw_key_req
          package: keymgr_pkg
          type: uni
          act: rcv
          width: 1
          inst_name: kmac
          default: ""
          top_signame: keymgr_kmac_key
          index: -1
        }
        {
          name: app
          struct: app
          package: kmac_pkg
          type: req_rsp
          act: rsp
          width: 3
          inst_name: kmac
          default: ""
          end_idx: -1
          top_type: one-to-N
          top_signame: kmac_app
          index: -1
        }
        {
          name: entropy
          struct: edn
          package: edn_pkg
          type: req_rsp
          act: req
          width: 1
          inst_name: kmac
          default: ""
          top_signame: edn0_edn
          index: 3
        }
        {
          name: idle
          struct: mubi4
          package: prim_mubi_pkg
          type: uni
          act: req
          width: 1
          inst_name: kmac
          default: ""
          top_signame: clkmgr_aon_idle
          index: -1
        }
        {
          name: en_masking
          struct: logic
          type: uni
          act: req
          width: 1
          inst_name: kmac
          default: ""
          package: ""
          end_idx: -1
          top_type: broadcast
          top_signame: kmac_en_masking
          index: -1
        }
        {
          name: lc_escalate_en
          struct: lc_tx
          package: lc_ctrl_pkg
          type: uni
          act: rcv
          width: 1
          default: lc_ctrl_pkg::Off
          inst_name: kmac
          top_signame: lc_ctrl_lc_escalate_en
          index: -1
        }
        {
          name: tl
          struct: tl
          package: tlul_pkg
          type: req_rsp
          act: rsp
          width: 1
          inst_name: kmac
          default: ""
          end_idx: -1
          top_signame: kmac_tl
          index: -1
        }
      ]
      base_addrs:
      {
        null: 0x41120000
      }
    }
    {
      name: otp_ctrl
      type: otp_ctrl
      clock_srcs:
      {
        clk_i: io_div4
        clk_edn_i: main
      }
      clock_group: secure
      reset_connections:
      {
        rst_ni:
        {
          name: lc_io_div4
          domain: "0"
        }
        rst_edn_ni:
        {
          name: lc
          domain: "0"
        }
      }
      base_addrs:
      {
        core: 0x40130000
        prim: 0x40138000
      }
      clock_connections:
      {
        clk_i: clkmgr_aon_clocks.clk_io_div4_secure
        clk_edn_i: clkmgr_aon_clocks.clk_main_secure
      }
      domain:
      [
        "0"
      ]
      param_decl: {}
      memory: {}
      param_list:
      [
        {
          name: MemInitFile
          desc: VMEM file to initialize the OTP macro.
          type: ""
          default: '''""'''
          expose: "true"
          name_top: OtpCtrlMemInitFile
        }
        {
          name: RndCnstLfsrSeed
          desc: Compile-time random bits for initial LFSR seed
          type: otp_ctrl_pkg::lfsr_seed_t
          randcount: 40
          randtype: data
          name_top: RndCnstOtpCtrlLfsrSeed
          default: 0xf565c1b87d
          randwidth: 40
        }
        {
          name: RndCnstLfsrPerm
          desc: Compile-time random permutation for LFSR output
          type: otp_ctrl_pkg::lfsr_perm_t
          randcount: 40
          randtype: perm
          name_top: RndCnstOtpCtrlLfsrPerm
          default: 0x4e741985e8113d58dd50a0d794c6c92ce1662014a408760088671610d7da
          randwidth: 240
        }
        {
          name: RndCnstScrmblKeyInit
          desc: Compile-time random permutation for scrambling key/nonce register reset value
          type: otp_ctrl_pkg::scrmbl_key_init_t
          randcount: 256
          randtype: data
          name_top: RndCnstOtpCtrlScrmblKeyInit
          default: 0xc81bded7282425b1bb59b801481ed5793accfb3af884ae378405dbcb5508cd
          randwidth: 256
        }
      ]
      inter_signal_list:
      [
        {
          name: otp_ext_voltage_h
          struct: ""
          type: io
          act: none
          width: 1
          default: "'0"
          inst_name: otp_ctrl
          package: ""
          external: true
          top_signame: otp_ext_voltage_h
          conn_type: false
          index: -1
        }
        {
          name: otp_ast_pwr_seq
          desc: Power sequencing signals to AST (VDD domain).
          struct: otp_ast_req
          package: otp_ctrl_pkg
          type: uni
          act: req
          width: 1
          default: "'0"
          inst_name: otp_ctrl
          external: true
          top_signame: otp_ctrl_otp_ast_pwr_seq
          conn_type: false
          index: -1
        }
        {
          name: otp_ast_pwr_seq_h
          desc: Power sequencing signals coming from AST (VCC domain).
          struct: otp_ast_rsp
          package: otp_ctrl_pkg
          type: uni
          act: rcv
          width: 1
          default: "'0"
          inst_name: otp_ctrl
          external: true
          top_signame: otp_ctrl_otp_ast_pwr_seq_h
          conn_type: false
          index: -1
        }
        {
          name: edn
          desc: Entropy request to the entropy distribution network for LFSR reseeding and ephemeral key derivation.
          struct: edn
          package: edn_pkg
          type: req_rsp
          act: req
          width: 1
          inst_name: otp_ctrl
          default: ""
          top_signame: edn0_edn
          index: 1
        }
        {
          name: pwr_otp
          desc: Initialization request/acknowledge from/to power manager.
          struct: pwr_otp
          package: pwrmgr_pkg
          type: req_rsp
          act: rsp
          width: 1
          default: "'0"
          inst_name: otp_ctrl
          top_signame: pwrmgr_aon_pwr_otp
          index: -1
        }
        {
          name: lc_otp_vendor_test
          desc: Vendor test control signals from/to the life cycle TAP.
          struct: lc_otp_vendor_test
          package: otp_ctrl_pkg
          type: req_rsp
          act: rsp
          width: 1
          default: "'0"
          inst_name: otp_ctrl
          top_signame: lc_ctrl_lc_otp_vendor_test
          index: -1
        }
        {
          name: lc_otp_program
          desc: Life cycle state transition interface.
          struct: lc_otp_program
          package: otp_ctrl_pkg
          type: req_rsp
          act: rsp
          width: 1
          default: "'0"
          inst_name: otp_ctrl
          top_signame: lc_ctrl_lc_otp_program
          index: -1
        }
        {
          name: otp_lc_data
          desc:
            '''
            Life cycle state output holding the current life cycle state,
            the value of the transition counter and the tokens needed for life cycle transitions.
            '''
          struct: otp_lc_data
          package: otp_ctrl_pkg
          type: uni
          act: req
          width: 1
          default: "'0"
          inst_name: otp_ctrl
          end_idx: -1
          top_type: broadcast
          top_signame: otp_ctrl_otp_lc_data
          index: -1
        }
        {
          name: lc_escalate_en
          desc:
            '''
            Life cycle escalation enable coming from life cycle controller.
            This signal moves all FSMs within OTP into the error state.
            '''
          struct: lc_tx
          package: lc_ctrl_pkg
          type: uni
          act: rcv
          width: 1
          default: lc_ctrl_pkg::Off
          inst_name: otp_ctrl
          top_signame: lc_ctrl_lc_escalate_en
          index: -1
        }
        {
          name: lc_creator_seed_sw_rw_en
          desc:
            '''
            Provision enable qualifier coming from life cycle controller.
            This signal enables SW read / write access to the RMA_TOKEN and CREATOR_ROOT_KEY_SHARE0 and CREATOR_ROOT_KEY_SHARE1.
            '''
          struct: lc_tx
          package: lc_ctrl_pkg
          type: uni
          act: rcv
          width: 1
          default: lc_ctrl_pkg::Off
          inst_name: otp_ctrl
          top_signame: lc_ctrl_lc_creator_seed_sw_rw_en
          index: -1
        }
        {
          name: lc_owner_seed_sw_rw_en
          desc:
            '''
            Provision enable qualifier coming from life cycle controller.
            This signal enables SW read / write access to the OWNER_SEED.
            '''
          struct: lc_tx
          package: lc_ctrl_pkg
          type: uni
          act: rcv
          width: 1
          default: lc_ctrl_pkg::Off
          inst_name: otp_ctrl
          index: -1
        }
        {
          name: lc_seed_hw_rd_en
          desc:
            '''
            Seed read enable coming from life cycle controller.
            This signal enables HW read access to the CREATOR_ROOT_KEY_SHARE0 and CREATOR_ROOT_KEY_SHARE1.
            '''
          struct: lc_tx
          package: lc_ctrl_pkg
          type: uni
          act: rcv
          width: 1
          default: lc_ctrl_pkg::Off
          inst_name: otp_ctrl
          top_signame: lc_ctrl_lc_seed_hw_rd_en
          index: -1
        }
        {
          name: lc_dft_en
          desc:
            '''
            Test enable qualifier coming from life cycle controller.
            This signals enables the TL-UL access port to the proprietary OTP IP.
            '''
          struct: lc_tx
          package: lc_ctrl_pkg
          type: uni
          act: rcv
          width: 1
          default: lc_ctrl_pkg::Off
          inst_name: otp_ctrl
          top_signame: lc_ctrl_lc_dft_en
          index: -1
        }
        {
          name: lc_check_byp_en
          desc:
            '''
            Life cycle partition check bypass signal.
            This signal causes the life cycle partition to bypass consistency checks during life cycle state transitions in order to prevent spurious consistency check failures.
            '''
          struct: lc_tx
          package: lc_ctrl_pkg
          type: uni
          act: rcv
          width: 1
          default: lc_ctrl_pkg::Off
          inst_name: otp_ctrl
          top_signame: lc_ctrl_lc_check_byp_en
          index: -1
        }
        {
          name: otp_keymgr_key
          desc: Key output to the key manager holding CREATOR_ROOT_KEY_SHARE0 and CREATOR_ROOT_KEY_SHARE1.
          struct: otp_keymgr_key
          package: otp_ctrl_pkg
          type: uni
          act: req
          width: 1
          default: "'0"
          inst_name: otp_ctrl
          end_idx: -1
          top_type: broadcast
          top_signame: otp_ctrl_otp_keymgr_key
          index: -1
        }
        {
          name: flash_otp_key
          desc: Key derivation interface for FLASH scrambling.
          struct: flash_otp_key
          package: otp_ctrl_pkg
          type: req_rsp
          act: rsp
          width: 1
          default: "'0"
          inst_name: otp_ctrl
          top_signame: flash_ctrl_otp
          index: -1
        }
        {
          name: sram_otp_key
          desc: Array with key derivation interfaces for SRAM scrambling devices.
          struct: sram_otp_key
          package: otp_ctrl_pkg
          type: req_rsp
          act: rsp
          width: 4
          default: "'0"
          inst_name: otp_ctrl
          end_idx: 3
          top_type: partial-one-to-N
          top_signame: otp_ctrl_sram_otp_key
          index: -1
        }
        {
          name: otbn_otp_key
          desc: Key derivation interface for OTBN scrambling devices.
          struct: otbn_otp_key
          package: otp_ctrl_pkg
          type: req_rsp
          act: rsp
          width: 1
          default: "'0"
          inst_name: otp_ctrl
          index: -1
        }
        {
          name: otp_broadcast
          desc: Output of the HW partitions with breakout data types.
          struct: otp_broadcast
          package: otp_ctrl_part_pkg
          type: uni
          act: req
          width: 1
          default: "'0"
          inst_name: otp_ctrl
          top_signame: otp_ctrl_otp_broadcast
          index: -1
        }
        {
          name: obs_ctrl
          desc: AST observability control signals.
          struct: ast_obs_ctrl
          package: ast_pkg
          type: uni
          act: rcv
          width: 1
          inst_name: otp_ctrl
          default: ""
          top_signame: ast_obs_ctrl
          index: -1
        }
        {
          name: otp_obs
          desc: AST observability bus.
          struct: logic
          type: uni
          act: req
          width: 8
          inst_name: otp_ctrl
          default: ""
          package: ""
          external: true
          top_signame: otp_obs
          conn_type: false
          index: -1
        }
        {
          name: core_tl
          struct: tl
          package: tlul_pkg
          type: req_rsp
          act: rsp
          width: 1
          inst_name: otp_ctrl
          default: ""
          end_idx: -1
          top_signame: otp_ctrl_core_tl
          index: -1
        }
        {
          name: prim_tl
          struct: tl
          package: tlul_pkg
          type: req_rsp
          act: rsp
          width: 1
          inst_name: otp_ctrl
          default: ""
          end_idx: -1
          top_signame: otp_ctrl_prim_tl
          index: -1
        }
      ]
    }
    {
      name: lc_ctrl
      type: lc_ctrl
      clock_srcs:
      {
        clk_i: io_div4
        clk_kmac_i: main
      }
      clock_group: secure
      reset_connections:
      {
        rst_ni:
        {
          name: lc_io_div4
          domain: "0"
        }
        rst_kmac_ni:
        {
          name: lc
          domain: "0"
        }
      }
      param_decl:
      {
        SecVolatileRawUnlockEn: top_pkg::SecVolatileRawUnlockEn
        SiliconCreatorId: 16'h 4001
        ProductId: 16'h 0002
        RevisionId: 8'h 01
        IdcodeValue: jtag_id_pkg::LC_CTRL_JTAG_IDCODE
      }
      clock_connections:
      {
        clk_i: clkmgr_aon_clocks.clk_io_div4_secure
        clk_kmac_i: clkmgr_aon_clocks.clk_main_secure
      }
      domain:
      [
        "0"
      ]
      memory: {}
      param_list:
      [
        {
          name: SecVolatileRawUnlockEn
          desc:
            '''
            Disable (0) or enable (1) volatile RAW UNLOCK capability.
            If enabled, it is possible to perform a volatile RAW -> TEST_UNLOCKED0 transition
            without programming the OTP. This is a useful fallback mode in case the OTP is
            not working correctly.

            IMPORTANT NOTE: This should only be used in test chips. The parameter must be set
            to 0 in production tapeouts since this weakens the security posture of the RAW
            UNLOCK mechanism.
            '''
          type: bit
          default: top_pkg::SecVolatileRawUnlockEn
          expose: "true"
          name_top: SecLcCtrlVolatileRawUnlockEn
        }
        {
          name: RndCnstLcKeymgrDivInvalid
          desc: Diversification value used for all invalid life cycle states.
          type: lc_ctrl_pkg::lc_keymgr_div_t
          randcount: 128
          randtype: data
          name_top: RndCnstLcCtrlLcKeymgrDivInvalid
          default: 0x6cd2ce715e7cceb1bc1c61b3d27bb8e8
          randwidth: 128
        }
        {
          name: RndCnstLcKeymgrDivTestUnlocked
          desc: Diversification value used for the TEST_UNLOCKED* life cycle states.
          type: lc_ctrl_pkg::lc_keymgr_div_t
          randcount: 128
          randtype: data
          name_top: RndCnstLcCtrlLcKeymgrDivTestUnlocked
          default: 0x398e880ecd252956ba81616362b27eaf
          randwidth: 128
        }
        {
          name: RndCnstLcKeymgrDivDev
          desc: Diversification value used for the DEV life cycle state.
          type: lc_ctrl_pkg::lc_keymgr_div_t
          randcount: 128
          randtype: data
          name_top: RndCnstLcCtrlLcKeymgrDivDev
          default: 0xb903ec79bddf0a4f7dff07db05de6391
          randwidth: 128
        }
        {
          name: RndCnstLcKeymgrDivProduction
          desc: Diversification value used for the PROD/PROD_END life cycle states.
          type: lc_ctrl_pkg::lc_keymgr_div_t
          randcount: 128
          randtype: data
          name_top: RndCnstLcCtrlLcKeymgrDivProduction
          default: 0xe4ee4d8a2c7d4022f16ed8a24f80eeb
          randwidth: 128
        }
        {
          name: RndCnstLcKeymgrDivRma
          desc: Diversification value used for the RMA life cycle state.
          type: lc_ctrl_pkg::lc_keymgr_div_t
          randcount: 128
          randtype: data
          name_top: RndCnstLcCtrlLcKeymgrDivRma
          default: 0xcf8299839c103eae3c2f18b4666b5e59
          randwidth: 128
        }
        {
          name: RndCnstInvalidTokens
          desc: Compile-time random bits used for invalid tokens in the token mux
          type: lc_ctrl_pkg::lc_token_mux_t
          randcount: 1024
          randtype: data
          name_top: RndCnstLcCtrlInvalidTokens
          default: 0xd16c252f9db7f094161d818dc161fe2600e05775da90406d9ccee3e43f132c3da4baa301df91954a617569cefc9183de700f5c0cae7ed7fe6c45d1534fd390c7b068cfe8968794de88e8ff4adc3d02ebfa0a1d5faa5ee00ca534911723e1ea0687402a816510c535a8164939d97df7421ad4d2c18b270d422ec39c41f727d130
          randwidth: 1024
        }
        {
          name: SiliconCreatorId
          desc: Chip generation number.
          type: logic [15:0]
          default: 16'h 4001
          expose: "true"
          name_top: LcCtrlSiliconCreatorId
        }
        {
          name: ProductId
          desc: Chip revision number.
          type: logic [15:0]
          default: 16'h 0002
          expose: "true"
          name_top: LcCtrlProductId
        }
        {
          name: RevisionId
          desc: Chip revision number.
          type: logic [7:0]
          default: 8'h 01
          expose: "true"
          name_top: LcCtrlRevisionId
        }
        {
          name: IdcodeValue
          desc: JTAG ID code.
          type: logic [31:0]
          default: jtag_id_pkg::LC_CTRL_JTAG_IDCODE
          expose: "true"
          name_top: LcCtrlIdcodeValue
        }
      ]
      inter_signal_list:
      [
        {
          name: jtag
          struct: jtag
          package: jtag_pkg
          type: req_rsp
          act: rsp
          width: 1
          inst_name: lc_ctrl
          default: ""
          top_signame: pinmux_aon_lc_jtag
          index: -1
        }
        {
          name: esc_scrap_state0_tx
          struct: esc_tx
          package: prim_esc_pkg
          type: uni
          act: rcv
          width: 1
          inst_name: lc_ctrl
          default: ""
          top_signame: alert_handler_esc_tx
          index: 1
        }
        {
          name: esc_scrap_state0_rx
          struct: esc_rx
          package: prim_esc_pkg
          type: uni
          act: req
          width: 1
          inst_name: lc_ctrl
          default: ""
          top_signame: alert_handler_esc_rx
          index: 1
        }
        {
          name: esc_scrap_state1_tx
          struct: esc_tx
          package: prim_esc_pkg
          type: uni
          act: rcv
          width: 1
          inst_name: lc_ctrl
          default: ""
          top_signame: alert_handler_esc_tx
          index: 2
        }
        {
          name: esc_scrap_state1_rx
          struct: esc_rx
          package: prim_esc_pkg
          type: uni
          act: req
          width: 1
          inst_name: lc_ctrl
          default: ""
          top_signame: alert_handler_esc_rx
          index: 2
        }
        {
          name: pwr_lc
          struct: pwr_lc
          package: pwrmgr_pkg
          type: req_rsp
          act: rsp
          width: 1
          inst_name: lc_ctrl
          default: ""
          top_signame: pwrmgr_aon_pwr_lc
          index: -1
        }
        {
          name: lc_otp_vendor_test
          struct: lc_otp_vendor_test
          package: otp_ctrl_pkg
          type: req_rsp
          act: req
          width: 1
          default: "'0"
          inst_name: lc_ctrl
          end_idx: -1
          top_signame: lc_ctrl_lc_otp_vendor_test
          index: -1
        }
        {
          name: otp_lc_data
          struct: otp_lc_data
          package: otp_ctrl_pkg
          type: uni
          act: rcv
          width: 1
          default: otp_ctrl_pkg::OTP_LC_DATA_DEFAULT
          inst_name: lc_ctrl
          top_signame: otp_ctrl_otp_lc_data
          index: -1
        }
        {
          name: lc_otp_program
          struct: lc_otp_program
          package: otp_ctrl_pkg
          type: req_rsp
          act: req
          width: 1
          default: "'0"
          inst_name: lc_ctrl
          end_idx: -1
          top_signame: lc_ctrl_lc_otp_program
          index: -1
        }
        {
          name: kmac_data
          struct: app
          package: kmac_pkg
          type: req_rsp
          act: req
          width: 1
          default: "'0"
          inst_name: lc_ctrl
          top_signame: kmac_app
          index: 1
        }
        {
          name: lc_dft_en
          struct: lc_tx
          package: lc_ctrl_pkg
          type: uni
          act: req
          width: 1
          default: lc_ctrl_pkg::Off
          inst_name: lc_ctrl
          end_idx: -1
          top_type: broadcast
          top_signame: lc_ctrl_lc_dft_en
          index: -1
        }
        {
          name: lc_nvm_debug_en
          struct: lc_tx
          package: lc_ctrl_pkg
          type: uni
          act: req
          width: 1
          default: lc_ctrl_pkg::Off
          inst_name: lc_ctrl
          end_idx: -1
          top_type: broadcast
          top_signame: lc_ctrl_lc_nvm_debug_en
          index: -1
        }
        {
          name: lc_hw_debug_en
          struct: lc_tx
          package: lc_ctrl_pkg
          type: uni
          act: req
          width: 1
          default: lc_ctrl_pkg::Off
          inst_name: lc_ctrl
          end_idx: -1
          top_type: broadcast
          top_signame: lc_ctrl_lc_hw_debug_en
          index: -1
        }
        {
          name: lc_cpu_en
          struct: lc_tx
          package: lc_ctrl_pkg
          type: uni
          act: req
          width: 1
          default: lc_ctrl_pkg::Off
          inst_name: lc_ctrl
          end_idx: -1
          top_type: broadcast
          top_signame: lc_ctrl_lc_cpu_en
          index: -1
        }
        {
          name: lc_keymgr_en
          struct: lc_tx
          package: lc_ctrl_pkg
          type: uni
          act: req
          width: 1
          default: lc_ctrl_pkg::Off
          inst_name: lc_ctrl
          end_idx: -1
          top_type: broadcast
          top_signame: lc_ctrl_lc_keymgr_en
          index: -1
        }
        {
          name: lc_escalate_en
          struct: lc_tx
          package: lc_ctrl_pkg
          type: uni
          act: req
          width: 1
          default: lc_ctrl_pkg::Off
          inst_name: lc_ctrl
          end_idx: -1
          top_type: broadcast
          top_signame: lc_ctrl_lc_escalate_en
          index: -1
        }
        {
          name: lc_clk_byp_req
          struct: lc_tx
          package: lc_ctrl_pkg
          type: uni
          act: req
          width: 1
          default: lc_ctrl_pkg::Off
          inst_name: lc_ctrl
          end_idx: -1
          top_type: broadcast
          top_signame: lc_ctrl_lc_clk_byp_req
          index: -1
        }
        {
          name: lc_clk_byp_ack
          struct: lc_tx
          package: lc_ctrl_pkg
          type: uni
          act: rcv
          width: 1
          default: lc_ctrl_pkg::Off
          inst_name: lc_ctrl
          end_idx: -1
          top_type: broadcast
          top_signame: lc_ctrl_lc_clk_byp_ack
          index: -1
        }
        {
          name: lc_flash_rma_req
          struct: lc_tx
          package: lc_ctrl_pkg
          type: uni
          act: req
          width: 1
          default: lc_ctrl_pkg::Off
          inst_name: lc_ctrl
          end_idx: -1
          top_type: broadcast
          top_signame: lc_ctrl_lc_flash_rma_req
          index: -1
        }
        {
          name: lc_flash_rma_ack
          struct: lc_tx
          package: lc_ctrl_pkg
          type: uni
          act: rcv
          width: 2
          default: lc_ctrl_pkg::On
          inst_name: lc_ctrl
          end_idx: 1
          top_type: partial-one-to-N
          top_signame: lc_ctrl_lc_flash_rma_ack
          index: -1
        }
        {
          name: lc_flash_rma_seed
          struct: lc_flash_rma_seed
          package: lc_ctrl_pkg
          type: uni
          act: req
          width: 1
          default: "'0"
          inst_name: lc_ctrl
          top_signame: flash_ctrl_rma_seed
          index: -1
        }
        {
          name: lc_check_byp_en
          struct: lc_tx
          package: lc_ctrl_pkg
          type: uni
          act: req
          width: 1
          default: lc_ctrl_pkg::Off
          inst_name: lc_ctrl
          end_idx: -1
          top_type: broadcast
          top_signame: lc_ctrl_lc_check_byp_en
          index: -1
        }
        {
          name: lc_creator_seed_sw_rw_en
          struct: lc_tx
          package: lc_ctrl_pkg
          type: uni
          act: req
          width: 1
          default: lc_ctrl_pkg::Off
          inst_name: lc_ctrl
          end_idx: -1
          top_type: broadcast
          top_signame: lc_ctrl_lc_creator_seed_sw_rw_en
          index: -1
        }
        {
          name: lc_owner_seed_sw_rw_en
          struct: lc_tx
          package: lc_ctrl_pkg
          type: uni
          act: req
          width: 1
          default: lc_ctrl_pkg::Off
          inst_name: lc_ctrl
          end_idx: -1
          top_type: broadcast
          top_signame: lc_ctrl_lc_owner_seed_sw_rw_en
          index: -1
        }
        {
          name: lc_iso_part_sw_rd_en
          struct: lc_tx
          package: lc_ctrl_pkg
          type: uni
          act: req
          width: 1
          default: lc_ctrl_pkg::Off
          inst_name: lc_ctrl
          end_idx: -1
          top_type: broadcast
          top_signame: lc_ctrl_lc_iso_part_sw_rd_en
          index: -1
        }
        {
          name: lc_iso_part_sw_wr_en
          struct: lc_tx
          package: lc_ctrl_pkg
          type: uni
          act: req
          width: 1
          default: lc_ctrl_pkg::Off
          inst_name: lc_ctrl
          end_idx: -1
          top_type: broadcast
          top_signame: lc_ctrl_lc_iso_part_sw_wr_en
          index: -1
        }
        {
          name: lc_seed_hw_rd_en
          struct: lc_tx
          package: lc_ctrl_pkg
          type: uni
          act: req
          width: 1
          default: lc_ctrl_pkg::Off
          inst_name: lc_ctrl
          end_idx: -1
          top_type: broadcast
          top_signame: lc_ctrl_lc_seed_hw_rd_en
          index: -1
        }
        {
          name: lc_keymgr_div
          struct: lc_keymgr_div
          package: lc_ctrl_pkg
          type: uni
          act: req
          width: 1
          default: "'0"
          inst_name: lc_ctrl
          end_idx: -1
          top_type: broadcast
          top_signame: lc_ctrl_lc_keymgr_div
          index: -1
        }
        {
          name: otp_device_id
          struct: otp_device_id
          package: otp_ctrl_pkg
          type: uni
          act: rcv
          width: 1
          default: "'0"
          inst_name: lc_ctrl
          top_signame: lc_ctrl_otp_device_id
          index: -1
        }
        {
          name: otp_manuf_state
          struct: otp_manuf_state
          package: otp_ctrl_pkg
          type: uni
          act: rcv
          width: 1
          default: "'0"
          inst_name: lc_ctrl
          top_signame: lc_ctrl_otp_manuf_state
          index: -1
        }
        {
          name: hw_rev
          struct: lc_hw_rev
          package: lc_ctrl_pkg
          type: uni
          act: req
          width: 1
          default: "'0"
          inst_name: lc_ctrl
          index: -1
        }
        {
          name: strap_en_override
          desc:
            '''
            This signal transitions from 0 -> 1 by the lc_ctrl manager after volatile RAW_UNLOCK in order to re-sample the HW straps.
            The signal stays at 1 until reset.
            Note that this is only used in test chips when SecVolatileRawUnlockEn = 1.
            Otherwise this signal is tied off to 0.
            '''
          struct: logic
          type: uni
          act: req
          width: 1
          default: 1'b0
          inst_name: lc_ctrl
          package: ""
          end_idx: -1
          top_type: broadcast
          top_signame: lc_ctrl_strap_en_override
          index: -1
        }
        {
          name: tl
          struct: tl
          package: tlul_pkg
          type: req_rsp
          act: rsp
          width: 1
          inst_name: lc_ctrl
          default: ""
          end_idx: -1
          top_signame: lc_ctrl_tl
          index: -1
        }
      ]
      base_addrs:
      {
        null: 0x40140000
      }
    }
    {
      name: alert_handler
      type: alert_handler
      clock_srcs:
      {
        clk_i: io_div4
        clk_edn_i: main
      }
      clock_group: secure
      reset_connections:
      {
        rst_ni:
        {
          name: lc_io_div4
          domain: "0"
        }
        rst_edn_ni:
        {
          name: lc
          domain: "0"
        }
      }
      attr: ipgen
      clock_connections:
      {
        clk_i: clkmgr_aon_clocks.clk_io_div4_secure
        clk_edn_i: clkmgr_aon_clocks.clk_main_secure
      }
      domain:
      [
        "0"
      ]
      param_decl: {}
      memory: {}
      param_list:
      [
        {
          name: RndCnstLfsrSeed
          desc: Compile-time random bits for initial LFSR seed
          type: alert_pkg::lfsr_seed_t
          randcount: 32
          randtype: data
          name_top: RndCnstAlertHandlerLfsrSeed
          default: 0xed9b18b9
          randwidth: 32
        }
        {
          name: RndCnstLfsrPerm
          desc: Compile-time random permutation for LFSR output
          type: alert_pkg::lfsr_perm_t
          randcount: 32
          randtype: perm
          name_top: RndCnstAlertHandlerLfsrPerm
          default: 0x599b03f520dbae21d893d7b3f947145558f2f101
          randwidth: 160
        }
      ]
      inter_signal_list:
      [
        {
          name: crashdump
          struct: alert_crashdump
          package: alert_pkg
          type: uni
          act: req
          width: 1
          inst_name: alert_handler
          default: ""
          end_idx: -1
          top_type: broadcast
          top_signame: alert_handler_crashdump
          index: -1
        }
        {
          name: edn
          struct: edn
          package: edn_pkg
          type: req_rsp
          act: req
          width: 1
          inst_name: alert_handler
          default: ""
          top_signame: edn0_edn
          index: 4
        }
        {
          name: esc_rx
          struct: esc_rx
          package: prim_esc_pkg
          type: uni
          act: rcv
          width: 4
          inst_name: alert_handler
          default: ""
          end_idx: -1
          top_type: one-to-N
          top_signame: alert_handler_esc_rx
          index: -1
        }
        {
          name: esc_tx
          struct: esc_tx
          package: prim_esc_pkg
          type: uni
          act: req
          width: 4
          inst_name: alert_handler
          default: ""
          end_idx: -1
          top_type: one-to-N
          top_signame: alert_handler_esc_tx
          index: -1
        }
        {
          name: tl
          struct: tl
          package: tlul_pkg
          type: req_rsp
          act: rsp
          width: 1
          inst_name: alert_handler
          default: ""
          end_idx: -1
          top_signame: alert_handler_tl
          index: -1
        }
      ]
      base_addrs:
      {
        null: 0x40150000
      }
    }
    {
      name: spi_host0
      type: spi_host
      clock_srcs:
      {
        clk_i: io
      }
      clock_group: peri
      reset_connections:
      {
        rst_ni:
        {
          name: spi_host0
          domain: "0"
        }
      }
      clock_connections:
      {
        clk_i: clkmgr_aon_clocks.clk_io_peri
      }
      domain:
      [
        "0"
      ]
      param_decl: {}
      param_list: []
      inter_signal_list:
      [
        {
          name: passthrough
          struct: passthrough
          package: spi_device_pkg
          type: req_rsp
          act: rsp
          width: 1
          inst_name: spi_host0
          default: ""
          top_signame: spi_device_passthrough
          index: -1
        }
        {
          name: tl
          struct: tl
          package: tlul_pkg
          type: req_rsp
          act: rsp
          width: 1
          inst_name: spi_host0
          default: ""
          end_idx: -1
          top_signame: spi_host0_tl
          index: -1
        }
      ]
      base_addrs:
      {
        null: 0x40300000
      }
    }
    {
      name: pwrmgr_aon
      type: pwrmgr
      clock_group: powerup
      clock_srcs:
      {
        clk_i: io_div4
        clk_slow_i: aon
        clk_lc_i: io_div4
        clk_esc_i:
        {
          clock: io_div4
          group: secure
        }
      }
      reset_connections:
      {
        rst_ni:
        {
          name: por_io_div4
          domain: Aon
        }
        rst_main_ni:
        {
          name: por_aon
          domain: "0"
        }
        rst_lc_ni:
        {
          name: lc_io_div4
          domain: Aon
        }
        rst_esc_ni:
        {
          name: lc_io_div4
          domain: Aon
        }
        rst_slow_ni:
        {
          name: por_aon
          domain: Aon
        }
      }
      domain:
      [
        Aon
        "0"
      ]
      attr: ipgen
      clock_connections:
      {
        clk_i: clkmgr_aon_clocks.clk_io_div4_powerup
        clk_slow_i: clkmgr_aon_clocks.clk_aon_powerup
        clk_lc_i: clkmgr_aon_clocks.clk_io_div4_powerup
        clk_esc_i: clkmgr_aon_clocks.clk_io_div4_secure
      }
      param_decl: {}
      param_list: []
      inter_signal_list:
      [
        {
          name: pwr_ast
          struct: pwr_ast
          package: pwrmgr_pkg
          type: req_rsp
          act: req
          width: 1
          inst_name: pwrmgr_aon
          default: ""
          external: true
          top_signame: pwrmgr_ast
          conn_type: false
          index: -1
        }
        {
          name: pwr_rst
          struct: pwr_rst
          package: pwrmgr_pkg
          type: req_rsp
          act: req
          width: 1
          inst_name: pwrmgr_aon
          default: ""
          end_idx: -1
          top_signame: pwrmgr_aon_pwr_rst
          index: -1
        }
        {
          name: pwr_clk
          struct: pwr_clk
          package: pwrmgr_pkg
          type: req_rsp
          act: req
          width: 1
          inst_name: pwrmgr_aon
          default: ""
          end_idx: -1
          top_signame: pwrmgr_aon_pwr_clk
          index: -1
        }
        {
          name: pwr_otp
          struct: pwr_otp
          package: pwrmgr_pkg
          type: req_rsp
          act: req
          width: 1
          inst_name: pwrmgr_aon
          default: ""
          end_idx: -1
          top_signame: pwrmgr_aon_pwr_otp
          index: -1
        }
        {
          name: pwr_lc
          struct: pwr_lc
          package: pwrmgr_pkg
          type: req_rsp
          act: req
          width: 1
          inst_name: pwrmgr_aon
          default: ""
          end_idx: -1
          top_signame: pwrmgr_aon_pwr_lc
          index: -1
        }
        {
          name: pwr_flash
          struct: pwr_flash
          package: pwrmgr_pkg
          type: uni
          act: rcv
          width: 1
          inst_name: pwrmgr_aon
          default: ""
          end_idx: -1
          top_type: broadcast
          top_signame: pwrmgr_aon_pwr_flash
          index: -1
        }
        {
          name: esc_rst_tx
          struct: esc_tx
          package: prim_esc_pkg
          type: uni
          act: rcv
          width: 1
          inst_name: pwrmgr_aon
          default: ""
          top_signame: alert_handler_esc_tx
          index: 3
        }
        {
          name: esc_rst_rx
          struct: esc_rx
          package: prim_esc_pkg
          type: uni
          act: req
          width: 1
          inst_name: pwrmgr_aon
          default: ""
          top_signame: alert_handler_esc_rx
          index: 3
        }
        {
          name: pwr_cpu
          struct: pwr_cpu
          package: pwrmgr_pkg
          type: uni
          act: rcv
          width: 1
          inst_name: pwrmgr_aon
          default: ""
          top_signame: rv_core_ibex_pwrmgr
          index: -1
        }
        {
          name: wakeups
          struct: logic
          type: uni
          act: rcv
          width: 3
          inst_name: pwrmgr_aon
          default: ""
          package: ""
          end_idx: -1
          top_type: one-to-N
          top_signame: pwrmgr_aon_wakeups
          index: -1
        }
        {
          name: rstreqs
          struct: logic
          type: uni
          act: rcv
          width: 1
          inst_name: pwrmgr_aon
          default: ""
          package: ""
          end_idx: -1
          top_type: broadcast
          top_signame: pwrmgr_aon_rstreqs
          index: -1
        }
        {
          name: ndmreset_req
          struct: logic
          type: uni
          act: rcv
          width: 1
          inst_name: pwrmgr_aon
          default: ""
          package: ""
          top_signame: rv_dm_ndmreset_req
          index: -1
        }
        {
          name: strap
          struct: logic
          type: uni
          act: req
          width: 1
          inst_name: pwrmgr_aon
          default: ""
          package: ""
          end_idx: -1
          top_type: broadcast
          top_signame: pwrmgr_aon_strap
          index: -1
        }
        {
          name: low_power
          struct: logic
          type: uni
          act: req
          width: 1
          inst_name: pwrmgr_aon
          default: ""
          package: ""
          end_idx: -1
          top_type: broadcast
          top_signame: pwrmgr_aon_low_power
          index: -1
        }
        {
          name: rom_ctrl
          struct: pwrmgr_data
          package: rom_ctrl_pkg
          type: uni
          act: rcv
          width: 1
          inst_name: pwrmgr_aon
          default: ""
          top_signame: rom_ctrl_pwrmgr_data
          index: -1
        }
        {
          name: fetch_en
          struct: lc_tx
          package: lc_ctrl_pkg
          type: uni
          act: req
          width: 1
          inst_name: pwrmgr_aon
          default: ""
          end_idx: -1
          top_type: broadcast
          top_signame: pwrmgr_aon_fetch_en
          index: -1
        }
        {
          name: lc_dft_en
          struct: lc_tx
          package: lc_ctrl_pkg
          type: uni
          act: rcv
          width: 1
          inst_name: pwrmgr_aon
          default: ""
          top_signame: lc_ctrl_lc_dft_en
          index: -1
        }
        {
          name: lc_hw_debug_en
          struct: lc_tx
          package: lc_ctrl_pkg
          type: uni
          act: rcv
          width: 1
          inst_name: pwrmgr_aon
          default: ""
          top_signame: lc_ctrl_lc_hw_debug_en
          index: -1
        }
        {
          name: sw_rst_req
          struct: mubi4
          package: prim_mubi_pkg
          type: uni
          act: rcv
          width: 1
          inst_name: pwrmgr_aon
          default: ""
          top_signame: rstmgr_aon_sw_rst_req
          index: -1
        }
        {
          name: tl
          struct: tl
          package: tlul_pkg
          type: req_rsp
          act: rsp
          width: 1
          inst_name: pwrmgr_aon
          default: ""
          end_idx: -1
          top_signame: pwrmgr_aon_tl
          index: -1
        }
      ]
      base_addrs:
      {
        null: 0x40400000
      }
    }
    {
      name: rstmgr_aon
      type: rstmgr
      clock_srcs:
      {
        clk_i:
        {
          clock: io_div4
          group: powerup
        }
        clk_por_i: io_div4
        clk_aon_i: aon
        clk_main_i: main
        clk_io_i: io
        clk_usb_i: usb
        clk_io_div2_i: io_div2
        clk_io_div4_i: io_div4
        clk_exp_i: exp
        clk_main_div2_i: main_div2
        clk_main_div10_i: main_div10
        clk_usb_div4_i: usb_div4
        clk_exp_div2_i: exp_div2
        clk_exp_div8_i: exp_div8
        clk_exp2_i: exp2
        clk_exp2_div2_i: exp2_div2
        clk_exp2_div6_i: exp2_div6
      }
      clock_group: powerup
      reset_connections:
      {
        rst_ni:
        {
          name: lc_io_div4
          domain: Aon
        }
        rst_por_ni:
        {
          name: por_io_div4
          domain: Aon
        }
      }
      domain:
      [
        Aon
        "0"
      ]
      attr: ipgen
      clock_connections:
      {
        clk_i: clkmgr_aon_clocks.clk_io_div4_powerup
        clk_por_i: clkmgr_aon_clocks.clk_io_div4_powerup
        clk_aon_i: clkmgr_aon_clocks.clk_aon_powerup
        clk_main_i: clkmgr_aon_clocks.clk_main_powerup
        clk_io_i: clkmgr_aon_clocks.clk_io_powerup
        clk_usb_i: clkmgr_aon_clocks.clk_usb_powerup
        clk_io_div2_i: clkmgr_aon_clocks.clk_io_div2_powerup
        clk_io_div4_i: clkmgr_aon_clocks.clk_io_div4_powerup
        clk_exp_i: clkmgr_aon_clocks.clk_exp_powerup
        clk_main_div2_i: clkmgr_aon_clocks.clk_main_div2_powerup
        clk_main_div10_i: clkmgr_aon_clocks.clk_main_div10_powerup
        clk_usb_div4_i: clkmgr_aon_clocks.clk_usb_div4_powerup
        clk_exp_div2_i: clkmgr_aon_clocks.clk_exp_div2_powerup
        clk_exp_div8_i: clkmgr_aon_clocks.clk_exp_div8_powerup
        clk_exp2_i: clkmgr_aon_clocks.clk_exp2_powerup
        clk_exp2_div2_i: clkmgr_aon_clocks.clk_exp2_div2_powerup
        clk_exp2_div6_i: clkmgr_aon_clocks.clk_exp2_div6_powerup
      }
      param_decl: {}
      memory: {}
      param_list:
      [
        {
          name: SecCheck
          desc:
            '''
            When 1, enable rstmgr reset consistency checks.
            When 0, there are no consistency checks.
            '''
          type: bit
          default: 1'b1
          expose: "true"
          name_top: SecRstmgrAonCheck
        }
        {
          name: SecMaxSyncDelay
          desc: The maximum synchronization delay for parent / child reset checks.
          type: int
          default: "2"
          expose: "true"
          name_top: SecRstmgrAonMaxSyncDelay
        }
      ]
      inter_signal_list:
      [
        {
          name: por_n
          desc:
            '''
            Root power on reset signals from ast.
            There is one root reset signal for each core power domain.
            '''
          struct: logic
          type: uni
          act: rcv
          width: 2
          inst_name: rstmgr_aon
          default: ""
          package: ""
          external: true
          top_signame: por_n
          conn_type: false
          index: -1
        }
        {
          name: pwr
          desc:
            '''
            Reset request signals from power manager.
            Power manager can request for specific domains of the lc/sys reset tree to assert.
            '''
          struct: pwr_rst
          type: req_rsp
          act: rsp
          width: 1
          inst_name: rstmgr_aon
          default: ""
          package: pwrmgr_pkg
          top_signame: pwrmgr_aon_pwr_rst
          index: -1
        }
        {
          name: resets
          desc: Leaf resets fed to the system.
          struct: rstmgr_out
          package: rstmgr_pkg
          type: uni
          act: req
          width: 1
          inst_name: rstmgr_aon
          default: ""
          top_signame: rstmgr_aon_resets
          index: -1
        }
        {
          name: rst_en
          desc: Low-power-group outputs used by alert handler.
          struct: rstmgr_rst_en
          package: rstmgr_pkg
          type: uni
          act: req
          width: 1
          inst_name: rstmgr_aon
          default: ""
          top_signame: rstmgr_aon_rst_en
          index: -1
        }
        {
          name: alert_dump
          desc: Alert handler crash dump information.
          struct: alert_crashdump
          package: alert_pkg
          type: uni
          act: rcv
          width: 1
          inst_name: rstmgr_aon
          default: ""
          top_signame: alert_handler_crashdump
          index: -1
        }
        {
          name: cpu_dump
          desc: Main processing element crash dump information.
          struct: cpu_crash_dump
          package: rv_core_ibex_pkg
          type: uni
          act: rcv
          width: 1
          inst_name: rstmgr_aon
          default: ""
          top_signame: rv_core_ibex_crash_dump
          index: -1
        }
        {
          name: sw_rst_req
          desc: Software requested system reset to pwrmgr.
          struct: mubi4
          package: prim_mubi_pkg
          type: uni
          act: req
          width: 1
          inst_name: rstmgr_aon
          default: ""
          end_idx: -1
          top_type: broadcast
          top_signame: rstmgr_aon_sw_rst_req
          index: -1
        }
        {
          name: tl
          struct: tl
          package: tlul_pkg
          type: req_rsp
          act: rsp
          width: 1
          inst_name: rstmgr_aon
          default: ""
          end_idx: -1
          top_signame: rstmgr_aon_tl
          index: -1
        }
      ]
      base_addrs:
      {
        null: 0x40410000
      }
    }
    {
      name: clkmgr_aon
      type: clkmgr
      clock_srcs:
      {
        clk_i: io_div4
        clk_main_i:
        {
          group: ast
          clock: main
        }
        clk_io_i:
        {
          group: ast
          clock: io
        }
        clk_usb_i:
        {
          group: ast
          clock: usb
        }
        clk_aon_i:
        {
          group: ast
          clock: aon
        }
        clk_exp_i:
        {
          group: ast
          clock: exp
        }
        clk_exp2_i:
        {
          group: ast
          clock: exp2
        }
      }
      clock_group: powerup
      reset_connections:
      {
        rst_ni:
        {
          name: lc_io_div4
          domain: Aon
        }
        rst_aon_ni:
        {
          name: lc_aon
          domain: Aon
        }
        rst_io_ni:
        {
          name: lc_io
          domain: Aon
        }
        rst_io_div2_ni:
        {
          name: lc_io_div2
          domain: Aon
        }
        rst_io_div4_ni:
        {
          name: lc_io_div4
          domain: Aon
        }
        rst_main_ni:
        {
          name: lc
          domain: Aon
        }
        rst_usb_ni:
        {
          name: lc_usb
          domain: Aon
        }
        rst_exp_ni:
        {
          name: lc_exp
          domain: Aon
        }
        rst_exp2_ni:
        {
          name: lc_exp2
          domain: Aon
        }
        rst_main_div2_ni:
        {
          name: lc_main_div2
          domain: Aon
        }
        rst_main_div10_ni:
        {
          name: lc_main_div10
          domain: Aon
        }
        rst_usb_div4_ni:
        {
          name: lc_usb_div4
          domain: Aon
        }
        rst_exp_div2_ni:
        {
          name: lc_exp_div2
          domain: Aon
        }
        rst_exp_div8_ni:
        {
          name: lc_exp_div8
          domain: Aon
        }
        rst_exp2_div2_ni:
        {
          name: lc_exp2_div2
          domain: Aon
        }
        rst_exp2_div6_ni:
        {
          name: lc_exp2_div6
          domain: Aon
        }
        rst_root_ni:
        {
          name: por_io_div4
          domain: Aon
        }
        rst_root_io_ni:
        {
          name: por_io
          domain: Aon
        }
        rst_root_io_div2_ni:
        {
          name: por_io_div2
          domain: Aon
        }
        rst_root_io_div4_ni:
        {
          name: por_io_div4
          domain: Aon
        }
        rst_root_main_ni:
        {
          name: por
          domain: Aon
        }
        rst_root_usb_ni:
        {
          name: por_usb
          domain: Aon
        }
        rst_root_exp_ni:
        {
          name: por_exp
          domain: Aon
        }
        rst_root_exp2_ni:
        {
          name: por_exp2
          domain: Aon
        }
        rst_root_main_div2_ni:
        {
          name: por_main_div2
          domain: Aon
        }
        rst_root_main_div10_ni:
        {
          name: por_main_div10
          domain: Aon
        }
        rst_root_usb_div4_ni:
        {
          name: por_usb_div4
          domain: Aon
        }
        rst_root_exp_div2_ni:
        {
          name: por_exp_div2
          domain: Aon
        }
        rst_root_exp_div8_ni:
        {
          name: por_exp_div8
          domain: Aon
        }
        rst_root_exp2_div2_ni:
        {
          name: por_exp2_div2
          domain: Aon
        }
        rst_root_exp2_div6_ni:
        {
          name: por_exp2_div6
          domain: Aon
        }
      }
      domain:
      [
        Aon
      ]
      attr: ipgen
      clock_connections:
      {
        clk_i: clkmgr_aon_clocks.clk_io_div4_powerup
        clk_main_i: clk_main_i
        clk_io_i: clk_io_i
        clk_usb_i: clk_usb_i
        clk_aon_i: clk_aon_i
        clk_exp_i: clk_exp_i
        clk_exp2_i: clk_exp2_i
      }
      param_decl: {}
      param_list: []
      inter_signal_list:
      [
        {
          name: clocks
          struct: clkmgr_out
          package: clkmgr_pkg
          type: uni
          act: req
          width: 1
          inst_name: clkmgr_aon
          default: ""
          top_signame: clkmgr_aon_clocks
          index: -1
        }
        {
          name: cg_en
          struct: clkmgr_cg_en
          package: clkmgr_pkg
          type: uni
          act: req
          width: 1
          inst_name: clkmgr_aon
          default: ""
          top_signame: clkmgr_aon_cg_en
          index: -1
        }
        {
          name: lc_hw_debug_en
          struct: lc_tx
          package: lc_ctrl_pkg
          type: uni
          act: rcv
          width: 1
          inst_name: clkmgr_aon
          default: ""
          top_signame: lc_ctrl_lc_hw_debug_en
          index: -1
        }
        {
          name: io_clk_byp_req
          struct: mubi4
          package: prim_mubi_pkg
          type: uni
          act: req
          width: 1
          inst_name: clkmgr_aon
          default: ""
          external: true
          top_signame: io_clk_byp_req
          conn_type: false
          index: -1
        }
        {
          name: io_clk_byp_ack
          struct: mubi4
          package: prim_mubi_pkg
          type: uni
          act: rcv
          width: 1
          inst_name: clkmgr_aon
          default: ""
          external: true
          top_signame: io_clk_byp_ack
          conn_type: false
          index: -1
        }
        {
          name: all_clk_byp_req
          struct: mubi4
          package: prim_mubi_pkg
          type: uni
          act: req
          width: 1
          inst_name: clkmgr_aon
          default: ""
          external: true
          top_signame: all_clk_byp_req
          conn_type: false
          index: -1
        }
        {
          name: all_clk_byp_ack
          struct: mubi4
          package: prim_mubi_pkg
          type: uni
          act: rcv
          width: 1
          inst_name: clkmgr_aon
          default: ""
          external: true
          top_signame: all_clk_byp_ack
          conn_type: false
          index: -1
        }
        {
          name: hi_speed_sel
          struct: mubi4
          package: prim_mubi_pkg
          type: uni
          act: req
          width: 1
          inst_name: clkmgr_aon
          default: ""
          external: true
          top_signame: hi_speed_sel
          conn_type: false
          index: -1
        }
        {
          name: div_step_down_req
          struct: mubi4
          package: prim_mubi_pkg
          type: uni
          act: rcv
          width: 1
          inst_name: clkmgr_aon
          default: ""
          external: true
          top_signame: div_step_down_req
          conn_type: false
          index: -1
        }
        {
          name: lc_clk_byp_req
          struct: lc_tx
          package: lc_ctrl_pkg
          type: uni
          act: rcv
          width: 1
          inst_name: clkmgr_aon
          default: ""
          top_signame: lc_ctrl_lc_clk_byp_req
          index: -1
        }
        {
          name: lc_clk_byp_ack
          struct: lc_tx
          package: lc_ctrl_pkg
          type: uni
          act: req
          width: 1
          inst_name: clkmgr_aon
          default: ""
          top_signame: lc_ctrl_lc_clk_byp_ack
          index: -1
        }
        {
          name: jitter_en
          struct: mubi4
          package: prim_mubi_pkg
          type: uni
          act: req
          width: 1
          inst_name: clkmgr_aon
          default: ""
          external: true
          top_signame: clk_main_jitter_en
          conn_type: false
          index: -1
        }
        {
          name: pwr
          struct: pwr_clk
          type: req_rsp
          act: rsp
          width: 1
          inst_name: clkmgr_aon
          default: ""
          package: pwrmgr_pkg
          top_signame: pwrmgr_aon_pwr_clk
          index: -1
        }
        {
          name: idle
          struct: mubi4
          package: prim_mubi_pkg
          type: uni
          act: rcv
          width: 1
          inst_name: clkmgr_aon
          default: ""
          end_idx: -1
          top_type: broadcast
          top_signame: clkmgr_aon_idle
          index: -1
        }
        {
          name: calib_rdy
          desc: Indicates clocks are calibrated and frequencies accurate
          struct: mubi4
          package: prim_mubi_pkg
          type: uni
          act: rcv
          width: 1
          default: prim_mubi_pkg::MuBi4True
          inst_name: clkmgr_aon
          external: true
          top_signame: calib_rdy
          conn_type: false
          index: -1
        }
        {
          name: tl
          struct: tl
          package: tlul_pkg
          type: req_rsp
          act: rsp
          width: 1
          inst_name: clkmgr_aon
          default: ""
          end_idx: -1
          top_signame: clkmgr_aon_tl
          index: -1
        }
      ]
      base_addrs:
      {
        null: 0x40420000
      }
    }
    {
      name: pinmux_aon
      type: pinmux
      clock_srcs:
      {
        clk_i: io_div4
        clk_aon_i: aon
      }
      clock_group: powerup
      reset_connections:
      {
        rst_ni:
        {
          name: lc_io_div4
          domain: Aon
        }
        rst_aon_ni:
        {
          name: lc_aon
          domain: Aon
        }
        rst_sys_ni:
        {
          name: sys_io_div4
          domain: Aon
        }
      }
      domain:
      [
        Aon
      ]
      attr: templated
      param_decl:
      {
        SecVolatileRawUnlockEn: top_pkg::SecVolatileRawUnlockEn
      }
      clock_connections:
      {
        clk_i: clkmgr_aon_clocks.clk_io_div4_powerup
        clk_aon_i: clkmgr_aon_clocks.clk_aon_powerup
      }
      memory: {}
      param_list:
      [
        {
          name: SecVolatileRawUnlockEn
          desc:
            '''
            Disable (0) or enable (1) volatile RAW UNLOCK capability.
            If enabled, the strap_en_override_i input can be used to re-sample the straps at runtime.

            IMPORTANT NOTE: This should only be used in test chips. The parameter must be set
            to 0 in production tapeouts since this weakens the security posture of the RAW
            UNLOCK mechanism.
            '''
          type: bit
          default: top_pkg::SecVolatileRawUnlockEn
          expose: "true"
          name_top: SecPinmuxAonVolatileRawUnlockEn
        }
        {
          name: TargetCfg
          desc: Target specific pinmux configuration.
          type: pinmux_pkg::target_cfg_t
          default: pinmux_pkg::DefaultTargetCfg
          expose: "true"
          name_top: PinmuxAonTargetCfg
        }
      ]
      inter_signal_list:
      [
        {
          name: lc_hw_debug_en
          desc: Debug enable qualifier coming from life cycle controller, used for HW strap qualification.
          struct: lc_tx
          package: lc_ctrl_pkg
          type: uni
          act: rcv
          width: 1
          default: lc_ctrl_pkg::Off
          inst_name: pinmux_aon
          top_signame: lc_ctrl_lc_hw_debug_en
          index: -1
        }
        {
          name: lc_dft_en
          desc: Test enable qualifier coming from life cycle controller, used for HW strap qualification.
          struct: lc_tx
          package: lc_ctrl_pkg
          type: uni
          act: rcv
          width: 1
          default: lc_ctrl_pkg::Off
          inst_name: pinmux_aon
          top_signame: lc_ctrl_lc_dft_en
          index: -1
        }
        {
          name: lc_escalate_en
          desc:
            '''
            Escalation enable signal coming from life cycle controller, used for invalidating
            the latched lc_hw_debug_en state inside the strap sampling logic.
            '''
          struct: lc_tx
          package: lc_ctrl_pkg
          type: uni
          act: rcv
          width: 1
          default: lc_ctrl_pkg::Off
          inst_name: pinmux_aon
          top_signame: lc_ctrl_lc_escalate_en
          index: -1
        }
        {
          name: lc_check_byp_en
          desc:
            '''
            Check bypass enable signal coming from life cycle controller, used for invalidating
            the latched lc_hw_debug_en state inside the strap sampling logic. This signal is asserted
            whenever the life cycle controller performs a life cycle transition. Its main use is
            to skip any background checks inside the life cycle partition of the OTP controller while
            a life cycle transition is in progress.
            '''
          struct: lc_tx
          package: lc_ctrl_pkg
          type: uni
          act: rcv
          width: 1
          default: lc_ctrl_pkg::Off
          inst_name: pinmux_aon
          top_signame: lc_ctrl_lc_check_byp_en
          index: -1
        }
        {
          name: pinmux_hw_debug_en
          desc:
            '''
            This is the latched version of lc_hw_debug_en_i. We use it exclusively to gate the JTAG
            signals and TAP side of the RV_DM so that RV_DM can remain live during an NDM reset cycle.
            '''
          struct: lc_tx
          package: lc_ctrl_pkg
          type: uni
          act: req
          width: 1
          default: lc_ctrl_pkg::Off
          inst_name: pinmux_aon
          end_idx: -1
          top_type: broadcast
          top_signame: pinmux_aon_pinmux_hw_debug_en
          index: -1
        }
        {
          name: lc_jtag
          desc: Qualified JTAG signals for life cycle controller TAP.
          struct: jtag
          package: jtag_pkg
          type: req_rsp
          act: req
          width: 1
          inst_name: pinmux_aon
          default: ""
          end_idx: -1
          top_signame: pinmux_aon_lc_jtag
          index: -1
        }
        {
          name: rv_jtag
          desc: Qualified JTAG signals for RISC-V processor TAP.
          struct: jtag
          package: jtag_pkg
          type: req_rsp
          act: req
          width: 1
          inst_name: pinmux_aon
          default: ""
          end_idx: -1
          top_signame: pinmux_aon_rv_jtag
          index: -1
        }
        {
          name: dft_jtag
          desc: Qualified JTAG signals for DFT TAP.
          struct: jtag
          package: jtag_pkg
          type: req_rsp
          act: req
          width: 1
          inst_name: pinmux_aon
          default: ""
          top_signame: pinmux_aon_dft_jtag
          index: -1
        }
        {
          name: dft_strap_test
          desc: Sampled DFT strap values, going to the DFT TAP.
          struct: dft_strap_test_req
          package: pinmux_pkg
          type: uni
          act: req
          width: 1
          default: "'0"
          inst_name: pinmux_aon
          external: true
          top_signame: dft_strap_test
          conn_type: false
          index: -1
        }
        {
          name: dft_hold_tap_sel
          desc: TAP selection hold indication, asserted by the DFT TAP during boundary scan.
          struct: logic
          type: uni
          act: rcv
          width: 1
          default: "'0"
          inst_name: pinmux_aon
          package: ""
          external: true
          top_signame: dft_hold_tap_sel
          conn_type: false
          index: -1
        }
        {
          name: sleep_en
          desc: Level signal that is asserted when the power manager enters sleep.
          struct: logic
          type: uni
          act: rcv
          width: 1
          default: 1'b0
          inst_name: pinmux_aon
          package: ""
          top_signame: pwrmgr_aon_low_power
          index: -1
        }
        {
          name: strap_en
          desc: This signal is pulsed high by the power manager after reset in order to sample the HW straps.
          struct: logic
          type: uni
          act: rcv
          width: 1
          default: 1'b0
          inst_name: pinmux_aon
          package: ""
          top_signame: pwrmgr_aon_strap
          index: -1
        }
        {
          name: strap_en_override
          desc:
            '''
            This signal transitions from 0 -> 1 by the lc_ctrl manager after volatile RAW_UNLOCK in order to re-sample the HW straps.
            The signal must stay at 1 until reset.
            Note that this is only used in test chips when SecVolatileRawUnlockEn = 1.
            Otherwise this signal is unused.
            '''
          struct: logic
          type: uni
          act: rcv
          width: 1
          default: 1'b0
          inst_name: pinmux_aon
          package: ""
          top_signame: lc_ctrl_strap_en_override
          index: -1
        }
        {
          name: pin_wkup_req
          desc: Wakeup request from wakeup detectors, to the power manager, running on the AON clock.
          struct: logic
          type: uni
          act: req
          width: 1
          default: 1'b0
          inst_name: pinmux_aon
          package: ""
          top_signame: pwrmgr_aon_wakeups
          index: 0
        }
        {
          name: usbdev_dppullup_en
          desc: Pullup enable signal coming from the USB IP.
          struct: logic
          type: uni
          act: rcv
          width: 1
          inst_name: pinmux_aon
          index: -1
        }
        {
          name: usbdev_dnpullup_en
          desc: Pullup enable signal coming from the USB IP.
          struct: logic
          type: uni
          act: rcv
          width: 1
          inst_name: pinmux_aon
          index: -1
        }
        {
          name: usb_dppullup_en
          desc: " Pullup enable signal going to USB PHY, needs to be maintained in low-power mode."
          struct: logic
          type: uni
          act: req
          width: 1
          default: 1'b0
          inst_name: pinmux_aon
          package: ""
          external: true
          top_signame: usb_dp_pullup_en
          conn_type: false
          index: -1
        }
        {
          name: usb_dnpullup_en
          desc: Pullup enable signal going to USB PHY, needs to be maintained in low-power mode.
          struct: logic
          type: uni
          act: req
          width: 1
          default: 1'b0
          inst_name: pinmux_aon
          package: ""
          external: true
          top_signame: usb_dn_pullup_en
          conn_type: false
          index: -1
        }
        {
          name: usb_wkup_req
          desc: Wakeup request from USB wakeup detector, going to the power manager, running on the AON clock.
          struct: logic
          type: uni
          act: req
          width: 1
          default: 1'b0
          inst_name: pinmux_aon
          package: ""
          top_signame: pwrmgr_aon_wakeups
          index: 1
        }
        {
          name: usbdev_suspend_req
          desc: Indicates whether USB is in suspended state, coming from the USB device.
          struct: logic
          type: uni
          act: rcv
          width: 1
          inst_name: pinmux_aon
          index: -1
        }
        {
          name: usbdev_wake_ack
          desc: Acknowledges the USB wakeup request, coming from the USB device.
          struct: logic
          type: uni
          act: rcv
          width: 1
          inst_name: pinmux_aon
          index: -1
        }
        {
          name: usbdev_bus_not_idle
          desc: Event signal that indicates that the USB was not idle while monitoring.
          struct: logic
          type: uni
          act: req
          width: 1
          default: 1'b0
          inst_name: pinmux_aon
          index: -1
        }
        {
          name: usbdev_bus_reset
          desc: Event signal that indicates that the USB issued a Bus Reset while monitoring.
          struct: logic
          type: uni
          act: req
          width: 1
          default: 1'b0
          inst_name: pinmux_aon
          index: -1
        }
        {
          name: usbdev_sense_lost
          desc: Event signal that indicates that USB SENSE signal was lost while monitoring.
          struct: logic
          type: uni
          act: req
          width: 1
          default: 1'b0
          inst_name: pinmux_aon
          index: -1
        }
        {
          name: usbdev_wake_detect_active
          desc: State debug information.
          struct: logic
          type: uni
          act: req
          width: 1
          default: 1'b0
          inst_name: pinmux_aon
          index: -1
        }
        {
          name: tl
          struct: tl
          package: tlul_pkg
          type: req_rsp
          act: rsp
          width: 1
          inst_name: pinmux_aon
          default: ""
          end_idx: -1
          top_signame: pinmux_aon_tl
          index: -1
        }
      ]
      base_addrs:
      {
        null: 0x40460000
      }
    }
    {
      name: aon_timer_aon
      type: aon_timer
      clock_srcs:
      {
        clk_i: io_div4
        clk_aon_i: aon
      }
      clock_group: timers
      reset_connections:
      {
        rst_ni:
        {
          name: lc_io_div4
          domain: Aon
        }
        rst_aon_ni:
        {
          name: lc_aon
          domain: Aon
        }
      }
      domain:
      [
        Aon
      ]
      clock_connections:
      {
        clk_i: clkmgr_aon_clocks.clk_io_div4_timers
        clk_aon_i: clkmgr_aon_clocks.clk_aon_timers
      }
      param_decl: {}
      param_list: []
      inter_signal_list:
      [
        {
          name: nmi_wdog_timer_bark
          struct: logic
          type: uni
          act: req
          width: 1
          default: 1'b0
          inst_name: aon_timer_aon
          package: ""
          end_idx: -1
          top_type: broadcast
          top_signame: aon_timer_aon_nmi_wdog_timer_bark
          index: -1
        }
        {
          name: wkup_req
          struct: logic
          type: uni
          act: req
          width: 1
          default: 1'b0
          inst_name: aon_timer_aon
          package: ""
          top_signame: pwrmgr_aon_wakeups
          index: 2
        }
        {
          name: aon_timer_rst_req
          struct: logic
          type: uni
          act: req
          width: 1
          default: 1'b0
          inst_name: aon_timer_aon
          package: ""
          top_signame: pwrmgr_aon_rstreqs
          index: -1
        }
        {
          name: lc_escalate_en
          struct: lc_tx
          package: lc_ctrl_pkg
          type: uni
          act: rcv
          width: 1
          default: lc_ctrl_pkg::Off
          inst_name: aon_timer_aon
          top_signame: lc_ctrl_lc_escalate_en
          index: -1
        }
        {
          name: sleep_mode
          struct: logic
          type: uni
          act: rcv
          width: 1
          inst_name: aon_timer_aon
          default: ""
          package: ""
          top_signame: pwrmgr_aon_low_power
          index: -1
        }
        {
          name: tl
          struct: tl
          package: tlul_pkg
          type: req_rsp
          act: rsp
          width: 1
          inst_name: aon_timer_aon
          default: ""
          end_idx: -1
          top_signame: aon_timer_aon_tl
          index: -1
        }
      ]
      base_addrs:
      {
        null: 0x40470000
      }
    }
    {
      name: ast
      type: ast
      clock_srcs:
      {
        clk_ast_tlul_i:
        {
          clock: io_div4
          group: infra
        }
        clk_ast_adc_i:
        {
          clock: aon
          group: peri
        }
        clk_ast_alert_i:
        {
          clock: io_div4
          group: secure
        }
        clk_ast_es_i:
        {
          clock: main
          group: secure
        }
        clk_ast_rng_i:
        {
          clock: main
          group: secure
        }
        clk_ast_usb_i:
        {
          clock: usb
          group: peri
        }
      }
      clock_group: secure
      reset_connections:
      {
        rst_ast_tlul_ni:
        {
          name: lc_io_div4
          domain: "0"
        }
        rst_ast_adc_ni:
        {
          name: lc_aon
          domain: Aon
        }
        rst_ast_alert_ni:
        {
          name: lc_io_div4
          domain: "0"
        }
        rst_ast_es_ni:
        {
          name: lc
          domain: "0"
        }
        rst_ast_rng_ni:
        {
          name: lc
          domain: "0"
        }
        rst_ast_usb_ni:
        {
          name: usb
          domain: "0"
        }
      }
      domain:
      [
        Aon
        "0"
      ]
      attr: reggen_only
      clock_connections:
      {
        clk_ast_tlul_i: clkmgr_aon_clocks.clk_io_div4_infra
        clk_ast_adc_i: clkmgr_aon_clocks.clk_aon_peri
        clk_ast_alert_i: clkmgr_aon_clocks.clk_io_div4_secure
        clk_ast_es_i: clkmgr_aon_clocks.clk_main_secure
        clk_ast_rng_i: clkmgr_aon_clocks.clk_main_secure
        clk_ast_usb_i: clkmgr_aon_clocks.clk_usb_peri
      }
      param_decl: {}
      param_list: []
      inter_signal_list:
      [
        {
          name: tl
          struct: tl
          package: tlul_pkg
          type: req_rsp
          act: rsp
          width: 1
          inst_name: ast
          index: -1
        }
      ]
      base_addrs:
      {
        null: 0x40480000
      }
    }
    {
      name: sram_ctrl_ret_aon
      type: sram_ctrl
      clock_srcs:
      {
        clk_i: io_div4
        clk_otp_i: io_div4
      }
      clock_group: infra
      reset_connections:
      {
        rst_ni:
        {
          name: lc_io_div4
          domain: Aon
        }
        rst_otp_ni:
        {
          name: lc_io_div4
          domain: Aon
        }
      }
      domain:
      [
        Aon
      ]
      param_decl:
      {
        InstrExec: "0"
      }
      base_addrs:
      {
        regs: 0x40500000
        ram: 0x40600000
      }
      memory:
      {
        ram:
        {
          label: ram_ret_aon
          swaccess: rw
          data_intg_passthru: "true"
          exec: True
          byte_write: True
          size: 0x1000
        }
      }
      clock_connections:
      {
        clk_i: clkmgr_aon_clocks.clk_io_div4_infra
        clk_otp_i: clkmgr_aon_clocks.clk_io_div4_infra
      }
      param_list:
      [
        {
          name: RndCnstSramKey
          desc: Compile-time random reset value for SRAM scrambling key.
          type: otp_ctrl_pkg::sram_key_t
          randcount: 128
          randtype: data
          name_top: RndCnstSramCtrlRetAonSramKey
          default: 0x9339ef142e028325714513bfdc2a062c
          randwidth: 128
        }
        {
          name: RndCnstSramNonce
          desc: Compile-time random reset value for SRAM scrambling nonce.
          type: otp_ctrl_pkg::sram_nonce_t
          randcount: 128
          randtype: data
          name_top: RndCnstSramCtrlRetAonSramNonce
          default: 0x2eb4ecdc716a92861ff7c06c6910e727
          randwidth: 128
        }
        {
          name: RndCnstLfsrSeed
          desc: Compile-time random bits for initial LFSR seed
          type: sram_ctrl_pkg::lfsr_seed_t
          randcount: 32
          randtype: data
          name_top: RndCnstSramCtrlRetAonLfsrSeed
          default: 0xcbed4ee2
          randwidth: 32
        }
        {
          name: RndCnstLfsrPerm
          desc: Compile-time random permutation for LFSR output
          type: sram_ctrl_pkg::lfsr_perm_t
          randcount: 32
          randtype: perm
          name_top: RndCnstSramCtrlRetAonLfsrPerm
          default: 0xd6f238b0468730f0c8e9283ce5fdb522a88ede76
          randwidth: 160
        }
        {
          name: MemSizeRam
          desc: Memory size of the RAM (in bytes).
          type: int
          name_top: MemSizeSramCtrlRetAonRam
          default: 4096
        }
        {
          name: InstrExec
          desc: Support execution from SRAM
          type: bit
          default: "0"
          expose: "true"
          name_top: SramCtrlRetAonInstrExec
        }
        {
          name: NumPrinceRoundsHalf
          desc: Number of PRINCE half rounds for the SRAM scrambling feature
          type: int
          default: "3"
          expose: "true"
          name_top: SramCtrlRetAonNumPrinceRoundsHalf
        }
      ]
      inter_signal_list:
      [
        {
          name: sram_otp_key
          struct: sram_otp_key
          package: otp_ctrl_pkg
          type: req_rsp
          act: req
          width: 1
          inst_name: sram_ctrl_ret_aon
          default: ""
          top_signame: otp_ctrl_sram_otp_key
          index: 1
        }
        {
          name: cfg
          struct: ram_1p_cfg
          package: prim_ram_1p_pkg
          type: uni
          act: rcv
          width: 1
          default: "'0"
          inst_name: sram_ctrl_ret_aon
          top_signame: ast_ram_1p_cfg
          index: -1
        }
        {
          name: lc_escalate_en
          struct: lc_tx
          package: lc_ctrl_pkg
          type: uni
          act: rcv
          width: 1
          default: lc_ctrl_pkg::Off
          inst_name: sram_ctrl_ret_aon
          top_signame: lc_ctrl_lc_escalate_en
          index: -1
        }
        {
          name: lc_hw_debug_en
          struct: lc_tx
          package: lc_ctrl_pkg
          type: uni
          act: rcv
          width: 1
          default: lc_ctrl_pkg::Off
          inst_name: sram_ctrl_ret_aon
          index: -1
        }
        {
          name: otp_en_sram_ifetch
          struct: mubi8
          package: prim_mubi_pkg
          type: uni
          act: rcv
          width: 1
          default: prim_mubi_pkg::MuBi8False
          inst_name: sram_ctrl_ret_aon
          index: -1
        }
        {
          name: regs_tl
          struct: tl
          package: tlul_pkg
          type: req_rsp
          act: rsp
          width: 1
          inst_name: sram_ctrl_ret_aon
          default: ""
          end_idx: -1
          top_signame: sram_ctrl_ret_aon_regs_tl
          index: -1
        }
        {
          name: ram_tl
          struct: tl
          package: tlul_pkg
          type: req_rsp
          act: rsp
          width: 1
          inst_name: sram_ctrl_ret_aon
          default: ""
          end_idx: -1
          top_signame: sram_ctrl_ret_aon_ram_tl
          index: -1
        }
      ]
    }
    {
      name: flash_ctrl
      type: flash_ctrl
      clock_srcs:
      {
        clk_i: main
        clk_otp_i: io_div4
      }
      clock_group: infra
      reset_connections:
      {
        rst_ni:
        {
          name: lc
          domain: "0"
        }
        rst_otp_ni:
        {
          name: lc_io_div4
          domain: "0"
        }
      }
      base_addrs:
      {
        core: 0x41000000
        prim: 0x41008000
        mem: 0x20000000
      }
      param_decl:
      {
        ProgFifoDepth: "4"
      }
      memory:
      {
        mem:
        {
          label: eflash
          swaccess: ro
          data_intg_passthru: "true"
          exec: True
          byte_write: False
          config:
          {
            banks: 2
            pages_per_bank: 256
            program_resolution: 8
            pgm_resolution_bytes: 64
            bytes_per_page: 2048
            bytes_per_bank: 524288
            size: 0x100000
          }
          size: 0x100000
        }
      }
      attr: ipgen
      clock_connections:
      {
        clk_i: clkmgr_aon_clocks.clk_main_infra
        clk_otp_i: clkmgr_aon_clocks.clk_io_div4_infra
      }
      domain:
      [
        "0"
      ]
      param_list:
      [
        {
          name: RndCnstAddrKey
          desc: Compile-time random bits for default address key
          type: flash_ctrl_pkg::flash_key_t
          randcount: 128
          randtype: data
          name_top: RndCnstFlashCtrlAddrKey
          default: 0xd0a3f6c9b71d03e571bee0e47e5b49e8
          randwidth: 128
        }
        {
          name: RndCnstDataKey
          desc: Compile-time random bits for default data key
          type: flash_ctrl_pkg::flash_key_t
          randcount: 128
          randtype: data
          name_top: RndCnstFlashCtrlDataKey
          default: 0xe3da39a52777dbcfd9e38d4d189ec4b
          randwidth: 128
        }
        {
          name: RndCnstAllSeeds
          desc: Compile-time random bits for default seeds
          type: flash_ctrl_pkg::all_seeds_t
          randcount: 512
          randtype: data
          name_top: RndCnstFlashCtrlAllSeeds
          default: 0x433e5314f88c893a6cb3fd30a87c38225a15108e992d14bf1225d4b19b23f40e358f1bf4fe1d5a50b10232a8b3c33a6017b97036561aa26231042404e5ef7464
          randwidth: 512
        }
        {
          name: RndCnstLfsrSeed
          desc: Compile-time random bits for initial LFSR seed
          type: flash_ctrl_pkg::lfsr_seed_t
          randcount: 32
          randtype: data
          name_top: RndCnstFlashCtrlLfsrSeed
          default: 0x5be00ea5
          randwidth: 32
        }
        {
          name: RndCnstLfsrPerm
          desc: Compile-time random permutation for LFSR output
          type: flash_ctrl_pkg::lfsr_perm_t
          randcount: 32
          randtype: perm
          name_top: RndCnstFlashCtrlLfsrPerm
          default: 0x1e56139348919bc4b94584eb48bc40f62fdfed96
          randwidth: 160
        }
        {
          name: SecScrambleEn
          desc: Compile-time option to enable flash scrambling
          type: bit
          default: "1"
          expose: "true"
          name_top: SecFlashCtrlScrambleEn
        }
        {
          name: ProgFifoDepth
          desc: Depth of program fifo
          type: int
          default: "4"
          expose: "true"
          name_top: FlashCtrlProgFifoDepth
        }
        {
          name: RdFifoDepth
          desc: Depth of read fifo
          type: int
          default: "16"
          expose: "true"
          name_top: FlashCtrlRdFifoDepth
        }
      ]
      inter_signal_list:
      [
        {
          name: otp
          struct: flash_otp_key
          package: otp_ctrl_pkg
          type: req_rsp
          act: req
          width: 1
          inst_name: flash_ctrl
          default: ""
          end_idx: -1
          top_signame: flash_ctrl_otp
          index: -1
        }
        {
          name: lc_nvm_debug_en
          struct: lc_tx
          package: lc_ctrl_pkg
          type: uni
          act: rcv
          width: 1
          inst_name: flash_ctrl
          default: ""
          top_signame: lc_ctrl_lc_nvm_debug_en
          index: -1
        }
        {
          name: flash_bist_enable
          struct: mubi4
          package: prim_mubi_pkg
          type: uni
          act: rcv
          width: 1
          inst_name: flash_ctrl
          default: ""
          external: true
          top_signame: flash_bist_enable
          conn_type: false
          index: -1
        }
        {
          name: flash_power_down_h
          struct: logic
          type: uni
          act: rcv
          width: 1
          inst_name: flash_ctrl
          default: ""
          package: ""
          external: true
          top_signame: flash_power_down_h
          conn_type: false
          index: -1
        }
        {
          name: flash_power_ready_h
          struct: logic
          type: uni
          act: rcv
          width: 1
          inst_name: flash_ctrl
          default: ""
          package: ""
          external: true
          top_signame: flash_power_ready_h
          conn_type: false
          index: -1
        }
        {
          name: flash_test_mode_a
          struct: ""
          type: io
          act: none
          width: 2
          inst_name: flash_ctrl
          default: ""
          package: ""
          external: true
          top_signame: flash_test_mode_a
          conn_type: false
          index: -1
        }
        {
          name: flash_test_voltage_h
          struct: ""
          type: io
          act: none
          width: 1
          inst_name: flash_ctrl
          default: ""
          package: ""
          external: true
          top_signame: flash_test_voltage_h
          conn_type: false
          index: -1
        }
        {
          name: lc_creator_seed_sw_rw_en
          struct: lc_tx
          package: lc_ctrl_pkg
          type: uni
          act: rcv
          width: 1
          inst_name: flash_ctrl
          default: ""
          top_signame: lc_ctrl_lc_creator_seed_sw_rw_en
          index: -1
        }
        {
          name: lc_owner_seed_sw_rw_en
          struct: lc_tx
          package: lc_ctrl_pkg
          type: uni
          act: rcv
          width: 1
          inst_name: flash_ctrl
          default: ""
          top_signame: lc_ctrl_lc_owner_seed_sw_rw_en
          index: -1
        }
        {
          name: lc_iso_part_sw_rd_en
          struct: lc_tx
          package: lc_ctrl_pkg
          type: uni
          act: rcv
          width: 1
          inst_name: flash_ctrl
          default: ""
          top_signame: lc_ctrl_lc_iso_part_sw_rd_en
          index: -1
        }
        {
          name: lc_iso_part_sw_wr_en
          struct: lc_tx
          package: lc_ctrl_pkg
          type: uni
          act: rcv
          width: 1
          inst_name: flash_ctrl
          default: ""
          top_signame: lc_ctrl_lc_iso_part_sw_wr_en
          index: -1
        }
        {
          name: lc_seed_hw_rd_en
          struct: lc_tx
          package: lc_ctrl_pkg
          type: uni
          act: rcv
          width: 1
          inst_name: flash_ctrl
          default: ""
          top_signame: lc_ctrl_lc_seed_hw_rd_en
          index: -1
        }
        {
          name: lc_escalate_en
          struct: lc_tx
          package: lc_ctrl_pkg
          type: uni
          act: rcv
          width: 1
          inst_name: flash_ctrl
          default: ""
          top_signame: lc_ctrl_lc_escalate_en
          index: -1
        }
        {
          name: rma_req
          struct: lc_tx
          package: lc_ctrl_pkg
          type: uni
          act: rcv
          width: 1
          inst_name: flash_ctrl
          default: ""
          top_signame: lc_ctrl_lc_flash_rma_req
          index: -1
        }
        {
          name: rma_ack
          struct: lc_tx
          package: lc_ctrl_pkg
          type: uni
          act: req
          width: 1
          inst_name: flash_ctrl
          default: ""
          top_signame: lc_ctrl_lc_flash_rma_ack
          index: 0
        }
        {
          name: rma_seed
          struct: lc_flash_rma_seed
          package: lc_ctrl_pkg
          type: uni
          act: rcv
          width: 1
          inst_name: flash_ctrl
          default: ""
          end_idx: -1
          top_type: broadcast
          top_signame: flash_ctrl_rma_seed
          index: -1
        }
        {
          name: pwrmgr
          struct: pwr_flash
          package: pwrmgr_pkg
          type: uni
          act: req
          width: 1
          inst_name: flash_ctrl
          default: ""
          top_signame: pwrmgr_aon_pwr_flash
          index: -1
        }
        {
          name: keymgr
          struct: keymgr_flash
          package: flash_ctrl_pkg
          type: uni
          act: req
          width: 1
          inst_name: flash_ctrl
          default: ""
          end_idx: -1
          top_type: broadcast
          top_signame: flash_ctrl_keymgr
          index: -1
        }
        {
          name: obs_ctrl
          struct: ast_obs_ctrl
          package: ast_pkg
          type: uni
          act: rcv
          width: 1
          inst_name: flash_ctrl
          default: ""
          top_signame: ast_obs_ctrl
          index: -1
        }
        {
          name: fla_obs
          struct: logic
          type: uni
          act: req
          width: 8
          inst_name: flash_ctrl
          default: ""
          package: ""
          external: true
          top_signame: flash_obs
          conn_type: false
          index: -1
        }
        {
          name: core_tl
          struct: tl
          package: tlul_pkg
          type: req_rsp
          act: rsp
          width: 1
          inst_name: flash_ctrl
          default: ""
          end_idx: -1
          top_signame: flash_ctrl_core_tl
          index: -1
        }
        {
          name: prim_tl
          struct: tl
          package: tlul_pkg
          type: req_rsp
          act: rsp
          width: 1
          inst_name: flash_ctrl
          default: ""
          end_idx: -1
          top_signame: flash_ctrl_prim_tl
          index: -1
        }
        {
          name: mem_tl
          struct: tl
          package: tlul_pkg
          type: req_rsp
          act: rsp
          width: 1
          inst_name: flash_ctrl
          default: ""
          end_idx: -1
          top_signame: flash_ctrl_mem_tl
          index: -1
        }
      ]
    }
    {
      name: rv_dm
      type: rv_dm
      clock_srcs:
      {
        clk_i: main
        clk_lc_i: main
      }
      clock_group: infra
      reset_connections:
      {
        rst_ni:
        {
          name: sys
          domain: "0"
        }
        rst_lc_ni:
        {
          name: lc
          domain: "0"
        }
      }
      param_decl:
      {
        IdcodeValue: jtag_id_pkg::RV_DM_JTAG_IDCODE
      }
      base_addrs:
      {
        mem: 0x00010000
        regs: 0x41200000
      }
      clock_connections:
      {
        clk_i: clkmgr_aon_clocks.clk_main_infra
        clk_lc_i: clkmgr_aon_clocks.clk_main_infra
      }
      domain:
      [
        "0"
      ]
      memory: {}
      param_list:
      [
        {
          name: IdcodeValue
          desc: RISC-V debug module JTAG ID code.
          type: logic [31:0]
          default: jtag_id_pkg::RV_DM_JTAG_IDCODE
          expose: "true"
          name_top: RvDmIdcodeValue
        }
      ]
      inter_signal_list:
      [
        {
          name: next_dm_addr
          desc:
            '''
            32bit word address of the next debug module.
            Set to 0x0 if this is the last debug module in the chain.
            '''
          struct: next_dm_addr
          package: rv_dm_pkg
          type: uni
          act: rcv
          width: 1
          default: "'0"
          inst_name: rv_dm
          index: -1
        }
        {
          name: jtag
          desc: JTAG signals for the RISC-V TAP.
          struct: jtag
          package: jtag_pkg
          type: req_rsp
          act: rsp
          width: 1
          inst_name: rv_dm
          default: ""
          top_signame: pinmux_aon_rv_jtag
          index: -1
        }
        {
          name: lc_hw_debug_en
          desc:
            '''
            Multibit life cycle hardware debug enable signal coming from life cycle controller,
            asserted when the hardware debug mechanisms are enabled in the system.
            '''
          struct: lc_tx
          package: lc_ctrl_pkg
          type: uni
          act: rcv
          width: 1
          default: lc_ctrl_pkg::Off
          inst_name: rv_dm
          top_signame: lc_ctrl_lc_hw_debug_en
          index: -1
        }
        {
          name: lc_dft_en
          desc:
            '''
            Multibit life cycle hardware debug enable signal coming from life cycle controller,
            asserted when the DFT mechanisms are enabled in the system.
            '''
          struct: lc_tx
          package: lc_ctrl_pkg
          type: uni
          act: rcv
          width: 1
          default: lc_ctrl_pkg::Off
          inst_name: rv_dm
          top_signame: lc_ctrl_lc_dft_en
          index: -1
        }
        {
          name: pinmux_hw_debug_en
          desc:
            '''
            Multibit life cycle hardware debug enable signal coming from pinmux.
            This is a latched version of the lc_hw_debug_en signal and is only used to
            gate the JTAG / TAP side of the RV_DM. It is used to keep a debug session live
            while the rest of the system undergoes an NDM reset.
            '''
          struct: lc_tx
          package: lc_ctrl_pkg
          type: uni
          act: rcv
          width: 1
          default: lc_ctrl_pkg::Off
          inst_name: rv_dm
          top_signame: pinmux_aon_pinmux_hw_debug_en
          index: -1
        }
        {
          name: otp_dis_rv_dm_late_debug
          struct: mubi8
          package: prim_mubi_pkg
          type: uni
          act: rcv
          width: 1
          default: prim_mubi_pkg::MuBi8False
          inst_name: rv_dm
          top_signame: rv_dm_otp_dis_rv_dm_late_debug
          index: -1
        }
        {
          name: unavailable
          desc:
            '''
            This signal indicates to the debug module that the main processor is not available
            for debug (e.g. due to a low-power state).
            '''
          struct: logic
          type: uni
          act: rcv
          width: 1
          default: 1'b0
          inst_name: rv_dm
          index: -1
        }
        {
          name: ndmreset_req
          desc: Non-debug module reset request going to the system reset infrastructure.
          struct: logic
          type: uni
          act: req
          width: 1
          inst_name: rv_dm
          default: ""
          package: ""
          end_idx: -1
          top_type: broadcast
          top_signame: rv_dm_ndmreset_req
          index: -1
        }
        {
          name: dmactive
          desc:
            '''
            This signal indicates whether the debug module is active and can be used to prevent
            power down of the core and bus-attached peripherals.
            '''
          struct: logic
          type: uni
          act: req
          width: 1
          inst_name: rv_dm
          index: -1
        }
        {
          name: debug_req
          desc: This is the debug request interrupt going to the main processor.
          struct: logic [rv_dm_reg_pkg::NrHarts-1:0]
          type: uni
          act: req
          width: 1
          inst_name: rv_dm
          default: ""
          package: ""
          end_idx: -1
          top_type: broadcast
          top_signame: rv_dm_debug_req
          index: -1
        }
        {
          name: sba_tl_h
          struct: tl
          package: tlul_pkg
          type: req_rsp
          act: req
          width: 1
          inst_name: rv_dm
          default: ""
          top_signame: main_tl_rv_dm__sba
          index: -1
        }
        {
          name: regs_tl_d
          struct: tl
          package: tlul_pkg
          type: req_rsp
          act: rsp
          width: 1
          inst_name: rv_dm
          default: ""
          end_idx: -1
          top_signame: rv_dm_regs_tl_d
          index: -1
        }
        {
          name: mem_tl_d
          struct: tl
          package: tlul_pkg
          type: req_rsp
          act: rsp
          width: 1
          inst_name: rv_dm
          default: ""
          end_idx: -1
          top_signame: rv_dm_mem_tl_d
          index: -1
        }
      ]
    }
    {
      name: rv_plic
      type: rv_plic
      clock_srcs:
      {
        clk_i: main
      }
      clock_group: secure
      reset_connections:
      {
        rst_ni:
        {
          name: lc
          domain: "0"
        }
      }
      attr: ipgen
      clock_connections:
      {
        clk_i: clkmgr_aon_clocks.clk_main_secure
      }
      domain:
      [
        "0"
      ]
      param_decl: {}
      param_list: []
      inter_signal_list:
      [
        {
          name: irq
          struct: logic
          type: uni
          act: req
          width: 1
          inst_name: rv_plic
          default: ""
          package: ""
          end_idx: -1
          top_type: broadcast
          top_signame: rv_plic_irq
          index: -1
        }
        {
          name: irq_id
          struct: logic
          type: uni
          act: req
          width: 1
          inst_name: rv_plic
          index: -1
        }
        {
          name: msip
          struct: logic
          type: uni
          act: req
          width: 1
          inst_name: rv_plic
          default: ""
          package: ""
          end_idx: -1
          top_type: broadcast
          top_signame: rv_plic_msip
          index: -1
        }
        {
          name: tl
          struct: tl
          package: tlul_pkg
          type: req_rsp
          act: rsp
          width: 1
          inst_name: rv_plic
          default: ""
          end_idx: -1
          top_signame: rv_plic_tl
          index: -1
        }
      ]
      base_addrs:
      {
        null: 0x48000000
      }
    }
    {
      name: keymgr
      type: keymgr
      clock_srcs:
      {
        clk_i: main
        clk_edn_i: main
      }
      clock_group: secure
      reset_connections:
      {
        rst_ni:
        {
          name: lc
          domain: "0"
        }
        rst_edn_ni:
        {
          name: lc
          domain: "0"
        }
      }
      clock_connections:
      {
        clk_i: clkmgr_aon_clocks.clk_main_secure
        clk_edn_i: clkmgr_aon_clocks.clk_main_secure
      }
      domain:
      [
        "0"
      ]
      param_decl: {}
      memory: {}
      param_list:
      [
        {
          name: UseOtpSeedsInsteadOfFlash
          desc:
            '''
            Flag indicating whether to use the creator / owner seeds provided
            via otp_key_i instead of the ones provided in flash_i. This option
            can be used in integrations where that do not have an embedded flash
            controller (in which case flash_i should just be tied off).
            '''
          type: bit
          default: "0"
          expose: "true"
          name_top: KeymgrUseOtpSeedsInsteadOfFlash
        }
        {
          name: KmacEnMasking
          desc: Flag indicating with kmac masking is enabled
          type: bit
          default: "1"
          expose: "true"
          name_top: KeymgrKmacEnMasking
        }
        {
          name: RndCnstLfsrSeed
          desc: Compile-time random bits for initial LFSR seed
          type: keymgr_pkg::lfsr_seed_t
          randcount: 64
          randtype: data
          name_top: RndCnstKeymgrLfsrSeed
          default: 0x67085e49639bc56b
          randwidth: 64
        }
        {
          name: RndCnstLfsrPerm
          desc: Compile-time random permutation for LFSR output
          type: keymgr_pkg::lfsr_perm_t
          randcount: 64
          randtype: perm
          name_top: RndCnstKeymgrLfsrPerm
          default: 0x909a523ef30a1cbcc8af4aa77d1743c3abb85014176c6fde959395c6df85ee00a8f56db9984cb785361cf22b0dd63680
          randwidth: 384
        }
        {
          name: RndCnstRandPerm
          desc: Compile-time random permutation for entropy used in share overriding
          type: keymgr_pkg::rand_perm_t
          randcount: 32
          randtype: perm
          name_top: RndCnstKeymgrRandPerm
          default: 0x6d751452c95939fc0613730af1f8f9bf7661024a
          randwidth: 160
        }
        {
          name: RndCnstRevisionSeed
          desc: Compile-time random bits for revision seed
          type: keymgr_pkg::seed_t
          randcount: 256
          randtype: data
          name_top: RndCnstKeymgrRevisionSeed
          default: 0x2d21f3cd9d71ca9790686d8ee0f7c7493081881eae14520cc2b374021de436f5
          randwidth: 256
        }
        {
          name: RndCnstCreatorIdentitySeed
          desc: Compile-time random bits for creator identity seed
          type: keymgr_pkg::seed_t
          randcount: 256
          randtype: data
          name_top: RndCnstKeymgrCreatorIdentitySeed
          default: 0x703142e83b671a6bce2387b97b6b2c03e1ae545b996acfdb3d12929b942f6d14
          randwidth: 256
        }
        {
          name: RndCnstOwnerIntIdentitySeed
          desc: Compile-time random bits for owner intermediate identity seed
          type: keymgr_pkg::seed_t
          randcount: 256
          randtype: data
          name_top: RndCnstKeymgrOwnerIntIdentitySeed
          default: 0xc2d1edd24d31ec5dabd85825526737c611fa0e7d754ae64a354cc7c16fa06ae2
          randwidth: 256
        }
        {
          name: RndCnstOwnerIdentitySeed
          desc: Compile-time random bits for owner identity seed
          type: keymgr_pkg::seed_t
          randcount: 256
          randtype: data
          name_top: RndCnstKeymgrOwnerIdentitySeed
          default: 0x8e208c1d5afc5f0d9de8d61cc3c920b2ed6566a1662940d8b187a1a31a45a09a
          randwidth: 256
        }
        {
          name: RndCnstSoftOutputSeed
          desc: Compile-time random bits for software generation seed
          type: keymgr_pkg::seed_t
          randcount: 256
          randtype: data
          name_top: RndCnstKeymgrSoftOutputSeed
          default: 0x6ebde6cf840d02166d836079645f80af64951722330edd3e68903f680ea72174
          randwidth: 256
        }
        {
          name: RndCnstHardOutputSeed
          desc: Compile-time random bits for hardware generation seed
          type: keymgr_pkg::seed_t
          randcount: 256
          randtype: data
          name_top: RndCnstKeymgrHardOutputSeed
          default: 0x50dc1f11aa9be9bce028acbb45fc85deaee9e9571e205cba9a4851b89a0ad9b8
          randwidth: 256
        }
        {
          name: RndCnstAesSeed
          desc: Compile-time random bits for generation seed when aes destination selected
          type: keymgr_pkg::seed_t
          randcount: 256
          randtype: data
          name_top: RndCnstKeymgrAesSeed
          default: 0xe60f7b4bcf8acbc5840e79cb084d95ca06120352218c90dfab74299e7882f53f
          randwidth: 256
        }
        {
          name: RndCnstKmacSeed
          desc: Compile-time random bits for generation seed when kmac destination selected
          type: keymgr_pkg::seed_t
          randcount: 256
          randtype: data
          name_top: RndCnstKeymgrKmacSeed
          default: 0x7a8ac1bc2fdebbdb82764e00b66018476ec7e9ae86d24fac08b704a4d6df17
          randwidth: 256
        }
        {
          name: RndCnstOtbnSeed
          desc: Compile-time random bits for generation seed when otbn destination selected
          type: keymgr_pkg::seed_t
          randcount: 256
          randtype: data
          name_top: RndCnstKeymgrOtbnSeed
          default: 0x92ad00e16cc7c015d85290553843b5b6af2bf8ac41cb2b75e1506639338be5dc
          randwidth: 256
        }
        {
          name: RndCnstCdi
          desc: Compile-time random bits for generation seed when no CDI is selected
          type: keymgr_pkg::seed_t
          randcount: 256
          randtype: data
          name_top: RndCnstKeymgrCdi
          default: 0xfa4bddbe5f3d5a9f9386da84ddb0c6ebd1e77067a438f6cb7f937d1e60908ab
          randwidth: 256
        }
        {
          name: RndCnstNoneSeed
          desc: Compile-time random bits for generation seed when no destination selected
          type: keymgr_pkg::seed_t
          randcount: 256
          randtype: data
          name_top: RndCnstKeymgrNoneSeed
          default: 0xb1b5fa56226ef0eed9d76b62e7b4e4466b9601dbb4592ff19842d51606fe22b8
          randwidth: 256
        }
      ]
      inter_signal_list:
      [
        {
          name: edn
          struct: edn
          package: edn_pkg
          type: req_rsp
          act: req
          width: 1
          inst_name: keymgr
          default: ""
          top_signame: edn0_edn
          index: 0
        }
        {
          name: aes_key
          struct: hw_key_req
          package: keymgr_pkg
          type: uni
          act: req
          width: 1
          inst_name: keymgr
          index: -1
        }
        {
          name: kmac_key
          struct: hw_key_req
          package: keymgr_pkg
          type: uni
          act: req
          width: 1
          inst_name: keymgr
          default: ""
          end_idx: -1
          top_type: broadcast
          top_signame: keymgr_kmac_key
          index: -1
        }
        {
          name: otbn_key
          struct: otbn_key_req
          package: keymgr_pkg
          type: uni
          act: req
          width: 1
          inst_name: keymgr
          index: -1
        }
        {
          name: kmac_data
          struct: app
          package: kmac_pkg
          type: req_rsp
          act: req
          width: 1
          inst_name: keymgr
          default: ""
          top_signame: kmac_app
          index: 0
        }
        {
          name: otp_key
          struct: otp_keymgr_key
          package: otp_ctrl_pkg
          type: uni
          act: rcv
          width: 1
          inst_name: keymgr
          default: ""
          top_signame: otp_ctrl_otp_keymgr_key
          index: -1
        }
        {
          name: otp_device_id
          struct: otp_device_id
          package: otp_ctrl_pkg
          type: uni
          act: rcv
          width: 1
          inst_name: keymgr
          default: ""
          top_signame: keymgr_otp_device_id
          index: -1
        }
        {
          name: flash
          struct: keymgr_flash
          package: flash_ctrl_pkg
          type: uni
          act: rcv
          width: 1
          inst_name: keymgr
          default: ""
          top_signame: flash_ctrl_keymgr
          index: -1
        }
        {
          name: lc_keymgr_en
          struct: lc_tx
          package: lc_ctrl_pkg
          type: uni
          act: rcv
          width: 1
          default: lc_ctrl_pkg::On
          inst_name: keymgr
          top_signame: lc_ctrl_lc_keymgr_en
          index: -1
        }
        {
          name: lc_keymgr_div
          struct: lc_keymgr_div
          package: lc_ctrl_pkg
          type: uni
          act: rcv
          width: 1
          inst_name: keymgr
          default: ""
          top_signame: lc_ctrl_lc_keymgr_div
          index: -1
        }
        {
          name: rom_digest
          struct: keymgr_data
          package: rom_ctrl_pkg
          type: uni
          act: rcv
          width: 1
          inst_name: keymgr
          default: ""
          top_signame: rom_ctrl_keymgr_data
          index: -1
        }
        {
          name: kmac_en_masking
          struct: logic
          type: uni
          act: rcv
          width: 1
          inst_name: keymgr
          default: ""
          package: ""
          top_signame: kmac_en_masking
          index: -1
        }
        {
          name: tl
          struct: tl
          package: tlul_pkg
          type: req_rsp
          act: rsp
          width: 1
          inst_name: keymgr
          default: ""
          end_idx: -1
          top_signame: keymgr_tl
          index: -1
        }
      ]
      base_addrs:
      {
        null: 0x41140000
      }
    }
    {
      name: csrng
      type: csrng
      clock_srcs:
      {
        clk_i: main
      }
      clock_group: secure
      reset_connections:
      {
        rst_ni:
        {
          name: lc
          domain: "0"
        }
      }
      clock_connections:
      {
        clk_i: clkmgr_aon_clocks.clk_main_secure
      }
      domain:
      [
        "0"
      ]
      param_decl: {}
      memory: {}
      param_list:
      [
        {
          name: RndCnstCsKeymgrDivNonProduction
          desc: Compile-time random bits for csrng state group diversification value
          type: csrng_pkg::cs_keymgr_div_t
          randcount: 384
          randtype: data
          name_top: RndCnstCsrngCsKeymgrDivNonProduction
          default: 0xed0e3f50759650ef701a4e6e4916eee56ef868e4092f9516cc8b20bed74b6a715b33cadb9092b1125746c49f15a16a2a
          randwidth: 384
        }
        {
          name: RndCnstCsKeymgrDivProduction
          desc: Compile-time random bits for csrng state group diversification value
          type: csrng_pkg::cs_keymgr_div_t
          randcount: 384
          randtype: data
          name_top: RndCnstCsrngCsKeymgrDivProduction
          default: 0x1fd01f8e09d92dd13e0298799d91c54bfd2a51f45aadf344c262bb0abde9b240d763da6c4250ba5a44a7d4f4d7f99b4a
          randwidth: 384
        }
        {
          name: SBoxImpl
          desc: Selection of the S-Box implementation. See aes_pkg.sv.
          type: aes_pkg::sbox_impl_e
          default: aes_pkg::SBoxImplCanright
          expose: "true"
          name_top: CsrngSBoxImpl
        }
      ]
      inter_signal_list:
      [
        {
          name: csrng_cmd
          struct: csrng
          package: csrng_pkg
          type: req_rsp
          act: rsp
          width: 2
          inst_name: csrng
          default: ""
          end_idx: 1
          top_type: partial-one-to-N
          top_signame: csrng_csrng_cmd
          index: -1
        }
        {
          name: entropy_src_hw_if
          struct: entropy_src_hw_if
          package: entropy_src_pkg
          type: req_rsp
          act: req
          width: 1
          inst_name: csrng
          default: ""
          end_idx: -1
          top_signame: csrng_entropy_src_hw_if
          index: -1
        }
        {
          name: cs_aes_halt
          desc:
            '''
            Coordinate activity between CSRNG's AES and Entropy Source's SHA3.
            When CSRNG gets a request and its AES is not active, it acknowledges and until the request has dropped neither runs its AES nor drops the acknowledge.
            '''
          struct: cs_aes_halt
          package: entropy_src_pkg
          type: req_rsp
          act: rsp
          width: 1
          inst_name: csrng
          default: ""
          end_idx: -1
          top_signame: csrng_cs_aes_halt
          index: -1
        }
        {
          name: otp_en_csrng_sw_app_read
          struct: mubi8
          package: prim_mubi_pkg
          type: uni
          act: rcv
          width: 1
          default: prim_mubi_pkg::MuBi8True
          inst_name: csrng
          top_signame: csrng_otp_en_csrng_sw_app_read
          index: -1
        }
        {
          name: lc_hw_debug_en
          struct: lc_tx
          package: lc_ctrl_pkg
          type: uni
          act: rcv
          width: 1
          default: lc_ctrl_pkg::Off
          inst_name: csrng
          top_signame: lc_ctrl_lc_hw_debug_en
          index: -1
        }
        {
          name: tl
          struct: tl
          package: tlul_pkg
          type: req_rsp
          act: rsp
          width: 1
          inst_name: csrng
          default: ""
          end_idx: -1
          top_signame: csrng_tl
          index: -1
        }
      ]
      base_addrs:
      {
        null: 0x41150000
      }
    }
    {
      name: entropy_src
      type: entropy_src
      clock_srcs:
      {
        clk_i: main
      }
      clock_group: secure
      reset_connections:
      {
        rst_ni:
        {
          name: lc
          domain: "0"
        }
      }
      clock_connections:
      {
        clk_i: clkmgr_aon_clocks.clk_main_secure
      }
      domain:
      [
        "0"
      ]
      param_decl: {}
      memory: {}
      param_list:
      [
        {
          name: EsFifoDepth
          desc: Number of 384-bit entries in the esfinal FIFO
          type: int
          default: "3"
          expose: "true"
          name_top: EntropySrcEsFifoDepth
        }
        {
          name: DistrFifoDepth
          desc: Number of 32-bit entries in the distr FIFO
          type: int unsigned
          default: "2"
          expose: "true"
          name_top: EntropySrcDistrFifoDepth
        }
        {
          name: Stub
          desc: Stub out the core of entropy_src logic
          type: bit
          default: "0"
          expose: "true"
          name_top: EntropySrcStub
        }
      ]
      inter_signal_list:
      [
        {
          name: entropy_src_hw_if
          struct: entropy_src_hw_if
          package: entropy_src_pkg
          type: req_rsp
          act: rsp
          width: 1
          inst_name: entropy_src
          default: ""
          top_signame: csrng_entropy_src_hw_if
          index: -1
        }
        {
          name: cs_aes_halt
          desc:
            '''
            Coordinate activity between CSRNG's AES and Entropy Source's SHA3.
            The idea is that Entropy Source requests CSRNG's AES to halt and waits for CSRNG to acknowledge before it starts its SHA3.
            While SHA3 runs, Entropy Source keeps the request high.
            CSRNG may not drop the acknowledge before Entropy Source drops the request.
            '''
          struct: cs_aes_halt
          package: entropy_src_pkg
          type: req_rsp
          act: req
          width: 1
          inst_name: entropy_src
          default: ""
          top_signame: csrng_cs_aes_halt
          index: -1
        }
        {
          name: entropy_src_rng
          struct: entropy_src_rng
          package: entropy_src_pkg
          type: req_rsp
          act: req
          width: 1
          inst_name: entropy_src
          default: ""
          external: true
          top_signame: es_rng
          conn_type: false
          index: -1
        }
        {
          name: entropy_src_xht
          struct: entropy_src_xht
          package: entropy_src_pkg
          type: req_rsp
          act: req
          width: 1
          inst_name: entropy_src
          index: -1
        }
        {
          name: otp_en_entropy_src_fw_read
          struct: mubi8
          package: prim_mubi_pkg
          type: uni
          act: rcv
          width: 1
          default: prim_mubi_pkg::MuBi8True
          inst_name: entropy_src
          index: -1
        }
        {
          name: otp_en_entropy_src_fw_over
          struct: mubi8
          package: prim_mubi_pkg
          type: uni
          act: rcv
          width: 1
          default: prim_mubi_pkg::MuBi8True
          inst_name: entropy_src
          index: -1
        }
        {
          name: rng_fips
          struct: logic
          type: uni
          act: req
          width: 1
          inst_name: entropy_src
          default: ""
          package: ""
          external: true
          top_signame: es_rng_fips
          conn_type: false
          index: -1
        }
        {
          name: tl
          struct: tl
          package: tlul_pkg
          type: req_rsp
          act: rsp
          width: 1
          inst_name: entropy_src
          default: ""
          end_idx: -1
          top_signame: entropy_src_tl
          index: -1
        }
      ]
      base_addrs:
      {
        null: 0x41160000
      }
    }
    {
      name: edn0
      type: edn
      clock_srcs:
      {
        clk_i: main
      }
      clock_group: secure
      reset_connections:
      {
        rst_ni:
        {
          name: lc
          domain: "0"
        }
      }
      clock_connections:
      {
        clk_i: clkmgr_aon_clocks.clk_main_secure
      }
      domain:
      [
        "0"
      ]
      param_decl: {}
      param_list: []
      inter_signal_list:
      [
        {
          name: csrng_cmd
          desc: EDN supports a signal CSRNG application interface.
          struct: csrng
          package: csrng_pkg
          type: req_rsp
          act: req
          width: 1
          inst_name: edn0
          default: ""
          top_signame: csrng_csrng_cmd
          index: 0
        }
        {
          name: edn
          desc:
            '''
            The collection of peripheral ports supported by edn. The width (4)
            indicates the number of peripheral ports on a single instance.
            Due to limitations in the parametrization of top-level interconnects
            this value is not currently parameterizable.  However, the number
            of peripheral ports may change in a future revision.
            '''
          struct: edn
          package: edn_pkg
          type: req_rsp
          act: rsp
          width: 8
          default: "'0"
          inst_name: edn0
          end_idx: 6
          top_type: partial-one-to-N
          top_signame: edn0_edn
          index: -1
        }
        {
          name: tl
          struct: tl
          package: tlul_pkg
          type: req_rsp
          act: rsp
          width: 1
          inst_name: edn0
          default: ""
          end_idx: -1
          top_signame: edn0_tl
          index: -1
        }
      ]
      base_addrs:
      {
        null: 0x41170000
      }
    }
    {
      name: sram_ctrl_main
      type: sram_ctrl
      clock_srcs:
      {
        clk_i: main
        clk_otp_i: io_div4
      }
      clock_group: infra
      reset_connections:
      {
        rst_ni:
        {
          name: lc
          domain: "0"
        }
        rst_otp_ni:
        {
          name: lc_io_div4
          domain: "0"
        }
      }
      param_decl:
      {
        InstrExec: "1"
        NumPrinceRoundsHalf: "2"
      }
      base_addrs:
      {
        regs: 0x411C0000
        ram: 0x10000000
      }
      memory:
      {
        ram:
        {
          label: ram_main
          swaccess: rw
          data_intg_passthru: "true"
          exec: True
          byte_write: True
          size: 0x20000
        }
      }
      clock_connections:
      {
        clk_i: clkmgr_aon_clocks.clk_main_infra
        clk_otp_i: clkmgr_aon_clocks.clk_io_div4_infra
      }
      domain:
      [
        "0"
      ]
      param_list:
      [
        {
          name: RndCnstSramKey
          desc: Compile-time random reset value for SRAM scrambling key.
          type: otp_ctrl_pkg::sram_key_t
          randcount: 128
          randtype: data
          name_top: RndCnstSramCtrlMainSramKey
          default: 0x6480da2d53e7ca15201a8f5653001011
          randwidth: 128
        }
        {
          name: RndCnstSramNonce
          desc: Compile-time random reset value for SRAM scrambling nonce.
          type: otp_ctrl_pkg::sram_nonce_t
          randcount: 128
          randtype: data
          name_top: RndCnstSramCtrlMainSramNonce
          default: 0x7f58c9e9946c11180407feb4710f404e
          randwidth: 128
        }
        {
          name: RndCnstLfsrSeed
          desc: Compile-time random bits for initial LFSR seed
          type: sram_ctrl_pkg::lfsr_seed_t
          randcount: 32
          randtype: data
          name_top: RndCnstSramCtrlMainLfsrSeed
          default: 0x6e4face5
          randwidth: 32
        }
        {
          name: RndCnstLfsrPerm
          desc: Compile-time random permutation for LFSR output
          type: sram_ctrl_pkg::lfsr_perm_t
          randcount: 32
          randtype: perm
          name_top: RndCnstSramCtrlMainLfsrPerm
          default: 0xe35da19444b219f89778dbc879da0e3abb19653
          randwidth: 160
        }
        {
          name: MemSizeRam
          desc: Memory size of the RAM (in bytes).
          type: int
          name_top: MemSizeSramCtrlMainRam
          default: 131072
        }
        {
          name: InstrExec
          desc: Support execution from SRAM
          type: bit
          default: "1"
          expose: "true"
          name_top: SramCtrlMainInstrExec
        }
        {
          name: NumPrinceRoundsHalf
          desc: Number of PRINCE half rounds for the SRAM scrambling feature
          type: int
          default: "2"
          expose: "true"
          name_top: SramCtrlMainNumPrinceRoundsHalf
        }
      ]
      inter_signal_list:
      [
        {
          name: sram_otp_key
          struct: sram_otp_key
          package: otp_ctrl_pkg
          type: req_rsp
          act: req
          width: 1
          inst_name: sram_ctrl_main
          default: ""
          top_signame: otp_ctrl_sram_otp_key
          index: 0
        }
        {
          name: cfg
          struct: ram_1p_cfg
          package: prim_ram_1p_pkg
          type: uni
          act: rcv
          width: 1
          default: "'0"
          inst_name: sram_ctrl_main
          top_signame: ast_ram_1p_cfg
          index: -1
        }
        {
          name: lc_escalate_en
          struct: lc_tx
          package: lc_ctrl_pkg
          type: uni
          act: rcv
          width: 1
          default: lc_ctrl_pkg::Off
          inst_name: sram_ctrl_main
          top_signame: lc_ctrl_lc_escalate_en
          index: -1
        }
        {
          name: lc_hw_debug_en
          struct: lc_tx
          package: lc_ctrl_pkg
          type: uni
          act: rcv
          width: 1
          default: lc_ctrl_pkg::Off
          inst_name: sram_ctrl_main
          top_signame: lc_ctrl_lc_hw_debug_en
          index: -1
        }
        {
          name: otp_en_sram_ifetch
          struct: mubi8
          package: prim_mubi_pkg
          type: uni
          act: rcv
          width: 1
          default: prim_mubi_pkg::MuBi8False
          inst_name: sram_ctrl_main
          top_signame: sram_ctrl_main_otp_en_sram_ifetch
          index: -1
        }
        {
          name: regs_tl
          struct: tl
          package: tlul_pkg
          type: req_rsp
          act: rsp
          width: 1
          inst_name: sram_ctrl_main
          default: ""
          end_idx: -1
          top_signame: sram_ctrl_main_regs_tl
          index: -1
        }
        {
          name: ram_tl
          struct: tl
          package: tlul_pkg
          type: req_rsp
          act: rsp
          width: 1
          inst_name: sram_ctrl_main
          default: ""
          end_idx: -1
          top_signame: sram_ctrl_main_ram_tl
          index: -1
        }
      ]
    }
    {
      name: rom_ctrl
      type: rom_ctrl
      clock_srcs:
      {
        clk_i: main
      }
      clock_group: infra
      reset_connections:
      {
        rst_ni:
        {
          name: lc
          domain: "0"
        }
      }
      base_addrs:
      {
        rom: 0x00008000
        regs: 0x411e0000
      }
      memory:
      {
        rom:
        {
          label: rom
          swaccess: ro
          data_intg_passthru: True
          exec: True
          byte_write: False
          size: 0x8000
        }
      }
      param_decl:
      {
        SecDisableScrambling: 1'b0
      }
      clock_connections:
      {
        clk_i: clkmgr_aon_clocks.clk_main_infra
      }
      domain:
      [
        "0"
      ]
      param_list:
      [
        {
          name: BootRomInitFile
          desc: Contents of ROM
          type: ""
          default: '''""'''
          expose: "true"
          name_top: RomCtrlBootRomInitFile
        }
        {
          name: RndCnstScrNonce
          desc: Fixed nonce used for address / data scrambling
          type: bit [63:0]
          randcount: 64
          randtype: data
          name_top: RndCnstRomCtrlScrNonce
          default: 0xeec6ba0486f07cff
          randwidth: 64
        }
        {
          name: RndCnstScrKey
          desc: Randomised constant used as a scrambling key for ROM data
          type: bit [127:0]
          randcount: 128
          randtype: data
          name_top: RndCnstRomCtrlScrKey
          default: 0xaf7b8b9213bd8dc7b927797c09dfeaf1
          randwidth: 128
        }
        {
          name: SecDisableScrambling
          desc:
            '''
            Disable scrambling and checking in rom_ctrl, turning the block into a
            simple ROM wrapper. This isn't intended for real chips, but is useful
            for small FPGA targets where there's not space for the PRINCE
            primitives.
            '''
          type: bit
          default: 1'b0
          expose: "true"
          name_top: SecRomCtrlDisableScrambling
        }
        {
          name: MemSizeRom
          desc: Memory size of the ROM (in bytes).
          type: int
          name_top: MemSizeRomCtrlRom
          default: 32768
        }
      ]
      inter_signal_list:
      [
        {
          name: rom_cfg
          struct: rom_cfg
          package: prim_rom_pkg
          type: uni
          act: rcv
          width: 1
          inst_name: rom_ctrl
          default: ""
          top_signame: ast_rom_cfg
          index: -1
        }
        {
          name: pwrmgr_data
          struct: pwrmgr_data
          package: rom_ctrl_pkg
          type: uni
          act: req
          width: 1
          inst_name: rom_ctrl
          default: ""
          end_idx: -1
          top_type: broadcast
          top_signame: rom_ctrl_pwrmgr_data
          index: -1
        }
        {
          name: keymgr_data
          struct: keymgr_data
          package: rom_ctrl_pkg
          type: uni
          act: req
          width: 1
          inst_name: rom_ctrl
          default: ""
          end_idx: -1
          top_type: broadcast
          top_signame: rom_ctrl_keymgr_data
          index: -1
        }
        {
          name: kmac_data
          struct: app
          package: kmac_pkg
          type: req_rsp
          act: req
          width: 1
          inst_name: rom_ctrl
          default: ""
          top_signame: kmac_app
          index: 2
        }
        {
          name: regs_tl
          struct: tl
          package: tlul_pkg
          type: req_rsp
          act: rsp
          width: 1
          inst_name: rom_ctrl
          default: ""
          end_idx: -1
          top_signame: rom_ctrl_regs_tl
          index: -1
        }
        {
          name: rom_tl
          struct: tl
          package: tlul_pkg
          type: req_rsp
          act: rsp
          width: 1
          inst_name: rom_ctrl
          default: ""
          end_idx: -1
          top_signame: rom_ctrl_rom_tl
          index: -1
        }
      ]
    }
    {
      name: rv_core_ibex
      type: rv_core_ibex
      param_decl:
      {
        PMPEnable: "1"
        PMPGranularity: "0"
        PMPNumRegions: "4"
        MHPMCounterNum: "2"
        MHPMCounterWidth: "32"
        RV32E: "0"
        RV32M: ibex_pkg::RV32MSingleCycle
        RV32B: ibex_pkg::RV32BOTEarlGrey
        RegFile: ibex_pkg::RegFileFF
        BranchTargetALU: "1"
        WritebackStage: "1"
        ICache: "0"
        ICacheECC: "0"
        ICacheScramble: "0"
        BranchPredictor: "0"
        DbgTriggerEn: "1"
        DbgHwBreakNum: "4"
        SecureIbex: "1"
        DmHaltAddr: tl_main_pkg::ADDR_SPACE_RV_DM__MEM + dm::HaltAddress[31:0]
        DmExceptionAddr: tl_main_pkg::ADDR_SPACE_RV_DM__MEM + dm::ExceptionAddress[31:0]
        PipeLine: "0"
      }
      clock_srcs:
      {
        clk_i: main
        clk_edn_i: main
        clk_esc_i:
        {
          clock: io_div4
          group: secure
        }
        clk_otp_i:
        {
          clock: io_div4
          group: secure
        }
      }
      clock_group: infra
      reset_connections:
      {
        rst_ni:
        {
          name: lc
          domain: "0"
        }
        rst_edn_ni:
        {
          name: lc
          domain: "0"
        }
        rst_esc_ni:
        {
          name: lc_io_div4
          domain: "0"
        }
        rst_otp_ni:
        {
          name: lc_io_div4
          domain: "0"
        }
      }
      clock_connections:
      {
        clk_i: clkmgr_aon_clocks.clk_main_infra
        clk_edn_i: clkmgr_aon_clocks.clk_main_infra
        clk_esc_i: clkmgr_aon_clocks.clk_io_div4_secure
        clk_otp_i: clkmgr_aon_clocks.clk_io_div4_secure
      }
      domain:
      [
        "0"
      ]
      memory: {}
      param_list:
      [
        {
          name: RndCnstLfsrSeed
          desc: Default seed of the PRNG used for random instructions.
          type: ibex_pkg::lfsr_seed_t
          randcount: 32
          randtype: data
          name_top: RndCnstRvCoreIbexLfsrSeed
          default: 0x272b92ab
          randwidth: 32
        }
        {
          name: RndCnstLfsrPerm
          desc: Permutation applied to the LFSR of the PRNG used for random instructions.
          type: ibex_pkg::lfsr_perm_t
          randcount: 32
          randtype: perm
          name_top: RndCnstRvCoreIbexLfsrPerm
          default: 0xeb1f416af1312685d732fee0e4d8bc1f8ea68038
          randwidth: 160
        }
        {
          name: RndCnstIbexKeyDefault
          desc: Default icache scrambling key
          type: logic [ibex_pkg::SCRAMBLE_KEY_W-1:0]
          randcount: 128
          randtype: data
          name_top: RndCnstRvCoreIbexIbexKeyDefault
          default: 0xaae70f22aaf748b57c320264e157e2c7
          randwidth: 128
        }
        {
          name: RndCnstIbexNonceDefault
          desc: Default icache scrambling nonce
          type: logic [ibex_pkg::SCRAMBLE_NONCE_W-1:0]
          randcount: 64
          randtype: data
          name_top: RndCnstRvCoreIbexIbexNonceDefault
          default: 0x4a28033261ee6cec
          randwidth: 64
        }
        {
          name: PMPEnable
          desc: Enable PMP
          type: bit
          default: "1"
          expose: "true"
          name_top: RvCoreIbexPMPEnable
        }
        {
          name: PMPGranularity
          desc: PMP Granularity
          type: int unsigned
          default: "0"
          expose: "true"
          name_top: RvCoreIbexPMPGranularity
        }
        {
          name: PMPNumRegions
          desc: PMP number of regions
          type: int unsigned
          default: "4"
          expose: "true"
          name_top: RvCoreIbexPMPNumRegions
        }
        {
          name: MHPMCounterNum
          desc: "Number of the MHPM counter "
          type: int unsigned
          default: "2"
          expose: "true"
          name_top: RvCoreIbexMHPMCounterNum
        }
        {
          name: MHPMCounterWidth
          desc: "Width of the MHPM Counter "
          type: int unsigned
          default: "32"
          expose: "true"
          name_top: RvCoreIbexMHPMCounterWidth
        }
        {
          name: RV32E
          desc: RV32E
          type: bit
          default: "0"
          expose: "true"
          name_top: RvCoreIbexRV32E
        }
        {
          name: RV32M
          desc: RV32M
          type: ibex_pkg::rv32m_e
          default: ibex_pkg::RV32MSingleCycle
          expose: "true"
          name_top: RvCoreIbexRV32M
        }
        {
          name: RV32B
          desc: RV32B
          type: ibex_pkg::rv32b_e
          default: ibex_pkg::RV32BOTEarlGrey
          expose: "true"
          name_top: RvCoreIbexRV32B
        }
        {
          name: RegFile
          desc: Reg file
          type: ibex_pkg::regfile_e
          default: ibex_pkg::RegFileFF
          expose: "true"
          name_top: RvCoreIbexRegFile
        }
        {
          name: BranchTargetALU
          desc: Branch target ALU
          type: bit
          default: "1"
          expose: "true"
          name_top: RvCoreIbexBranchTargetALU
        }
        {
          name: WritebackStage
          desc: Write back stage
          type: bit
          default: "1"
          expose: "true"
          name_top: RvCoreIbexWritebackStage
        }
        {
          name: ICache
          desc: Instruction cache
          type: bit
          default: "0"
          expose: "true"
          name_top: RvCoreIbexICache
        }
        {
          name: ICacheECC
          desc: Instruction cache ECC
          type: bit
          default: "0"
          expose: "true"
          name_top: RvCoreIbexICacheECC
        }
        {
          name: ICacheScramble
          desc: Scramble instruction cach
          type: bit
          default: "0"
          expose: "true"
          name_top: RvCoreIbexICacheScramble
        }
        {
          name: BranchPredictor
          desc: Branch predictor
          type: bit
          default: "0"
          expose: "true"
          name_top: RvCoreIbexBranchPredictor
        }
        {
          name: DbgTriggerEn
          desc: Enable degug trigger
          type: bit
          default: "1"
          expose: "true"
          name_top: RvCoreIbexDbgTriggerEn
        }
        {
          name: DbgHwBreakNum
          desc: Number of debug hardware break
          type: int
          default: "4"
          expose: "true"
          name_top: RvCoreIbexDbgHwBreakNum
        }
        {
          name: SecureIbex
          desc: "Width of the MHPM Counter "
          type: bit
          default: "1"
          expose: "true"
          name_top: RvCoreIbexSecureIbex
        }
        {
          name: DmHaltAddr
          desc: Halt address
          type: int unsigned
          default: tl_main_pkg::ADDR_SPACE_RV_DM__MEM + dm::HaltAddress[31:0]
          expose: "true"
          name_top: RvCoreIbexDmHaltAddr
        }
        {
          name: DmExceptionAddr
          desc: Exception address
          type: int unsigned
          default: tl_main_pkg::ADDR_SPACE_RV_DM__MEM + dm::ExceptionAddress[31:0]
          expose: "true"
          name_top: RvCoreIbexDmExceptionAddr
        }
        {
          name: PipeLine
          desc: Pipe line
          type: bit
          default: "0"
          expose: "true"
          name_top: RvCoreIbexPipeLine
        }
      ]
      inter_signal_list:
      [
        {
          name: rst_cpu_n
          struct: logic
          type: uni
          act: req
          width: 1
          inst_name: rv_core_ibex
          index: -1
        }
        {
          name: ram_cfg
          struct: ram_1p_cfg
          package: prim_ram_1p_pkg
          type: uni
          act: rcv
          width: 1
          inst_name: rv_core_ibex
          default: ""
          top_signame: ast_ram_1p_cfg
          index: -1
        }
        {
          name: hart_id
          struct: logic
          type: uni
          act: rcv
          width: 32
          inst_name: rv_core_ibex
          default: ""
          package: ""
          top_signame: rv_core_ibex_hart_id
          index: -1
        }
        {
          name: boot_addr
          struct: logic
          type: uni
          act: rcv
          width: 32
          inst_name: rv_core_ibex
          default: ""
          package: ""
          top_signame: rv_core_ibex_boot_addr
          index: -1
        }
        {
          name: irq_software
          struct: logic
          type: uni
          act: rcv
          width: 1
          inst_name: rv_core_ibex
          default: ""
          package: ""
          top_signame: rv_plic_msip
          index: -1
        }
        {
          name: irq_timer
          struct: logic
          type: uni
          act: rcv
          width: 1
          inst_name: rv_core_ibex
          default: ""
          package: ""
          top_signame: rv_core_ibex_irq_timer
          index: -1
        }
        {
          name: irq_external
          struct: logic
          type: uni
          act: rcv
          width: 1
          inst_name: rv_core_ibex
          default: ""
          package: ""
          top_signame: rv_plic_irq
          index: -1
        }
        {
          name: esc_tx
          struct: esc_tx
          package: prim_esc_pkg
          type: uni
          act: rcv
          width: 1
          inst_name: rv_core_ibex
          default: ""
          top_signame: alert_handler_esc_tx
          index: 0
        }
        {
          name: esc_rx
          struct: esc_rx
          package: prim_esc_pkg
          type: uni
          act: req
          width: 1
          inst_name: rv_core_ibex
          default: ""
          top_signame: alert_handler_esc_rx
          index: 0
        }
        {
          name: debug_req
          struct: logic
          type: uni
          act: rcv
          width: 1
          inst_name: rv_core_ibex
          default: ""
          package: ""
          top_signame: rv_dm_debug_req
          index: -1
        }
        {
          name: crash_dump
          struct: cpu_crash_dump
          package: rv_core_ibex_pkg
          type: uni
          act: req
          width: 1
          inst_name: rv_core_ibex
          default: ""
          end_idx: -1
          top_type: broadcast
          top_signame: rv_core_ibex_crash_dump
          index: -1
        }
        {
          name: lc_cpu_en
          struct: lc_tx
          package: lc_ctrl_pkg
          type: uni
          act: rcv
          width: 1
          inst_name: rv_core_ibex
          default: ""
          top_signame: lc_ctrl_lc_cpu_en
          index: -1
        }
        {
          name: pwrmgr_cpu_en
          struct: lc_tx
          package: lc_ctrl_pkg
          type: uni
          act: rcv
          width: 1
          inst_name: rv_core_ibex
          default: ""
          top_signame: pwrmgr_aon_fetch_en
          index: -1
        }
        {
          name: pwrmgr
          struct: pwr_cpu
          package: pwrmgr_pkg
          type: uni
          act: req
          width: 1
          inst_name: rv_core_ibex
          default: ""
          end_idx: -1
          top_type: broadcast
          top_signame: rv_core_ibex_pwrmgr
          index: -1
        }
        {
          name: nmi_wdog
          struct: logic
          type: uni
          act: rcv
          width: 1
          inst_name: rv_core_ibex
          default: ""
          package: ""
          top_signame: aon_timer_aon_nmi_wdog_timer_bark
          index: -1
        }
        {
          name: edn
          struct: edn
          package: edn_pkg
          type: req_rsp
          act: req
          width: 1
          inst_name: rv_core_ibex
          default: ""
          top_signame: edn0_edn
          index: 5
        }
        {
          name: icache_otp_key
          struct: sram_otp_key
          package: otp_ctrl_pkg
          type: req_rsp
          act: req
          width: 1
          inst_name: rv_core_ibex
          default: ""
          top_signame: otp_ctrl_sram_otp_key
          index: 2
        }
        {
          name: fpga_info
          struct: logic
          type: uni
          act: rcv
          width: 32
          inst_name: rv_core_ibex
          default: ""
          package: ""
          external: true
          top_signame: fpga_info
          conn_type: false
          index: -1
        }
        {
          name: corei_tl_h
          struct: tl
          package: tlul_pkg
          type: req_rsp
          act: req
          width: 1
          inst_name: rv_core_ibex
          default: ""
          top_signame: main_tl_rv_core_ibex__corei
          index: -1
        }
        {
          name: cored_tl_h
          struct: tl
          package: tlul_pkg
          type: req_rsp
          act: req
          width: 1
          inst_name: rv_core_ibex
          default: ""
          top_signame: main_tl_rv_core_ibex__cored
          index: -1
        }
        {
          name: cfg_tl_d
          struct: tl
          package: tlul_pkg
          type: req_rsp
          act: rsp
          width: 1
          inst_name: rv_core_ibex
          default: ""
          end_idx: -1
          top_signame: rv_core_ibex_cfg_tl_d
          index: -1
        }
      ]
      base_addrs:
      {
        cfg: 0x411F0000
      }
    }
  ]
  memory: []
  port:
  [
    {
      name: ast
      inter_signal_list:
      [
        {
          struct: edn
          type: req_rsp
          name: edn
          act: rsp
          package: edn_pkg
          inst_name: ast
          width: 1
          default: ""
          top_signame: edn0_edn
          index: 2
          external: true
          conn_type: true
        }
        {
          struct: lc_tx
          type: uni
          name: lc_dft_en
          act: req
          package: lc_ctrl_pkg
          inst_name: ast
          width: 1
          default: ""
          top_signame: lc_ctrl_lc_dft_en
          index: -1
          external: true
          conn_type: true
        }
        {
          struct: ram_1p_cfg
          package: prim_ram_1p_pkg
          type: uni
          name: ram_1p_cfg
          act: rcv
          inst_name: ast
          width: 1
          default: ""
          end_idx: -1
          top_type: broadcast
          top_signame: ast_ram_1p_cfg
          index: -1
          external: true
          conn_type: true
        }
        {
          struct: ram_2p_cfg
          package: prim_ram_2p_pkg
          type: uni
          name: spi_ram_2p_cfg
          act: rcv
          inst_name: ast
          width: 1
          default: ""
          end_idx: -1
          top_type: broadcast
          top_signame: ast_spi_ram_2p_cfg
          index: -1
          external: true
          conn_type: true
        }
        {
          struct: ram_1p_cfg
          package: prim_ram_1p_pkg
          type: uni
          name: usb_ram_1p_cfg
          act: rcv
          inst_name: ast
          index: -1
        }
        {
          struct: rom_cfg
          package: prim_rom_pkg
          type: uni
          name: rom_cfg
          act: rcv
          inst_name: ast
          width: 1
          default: ""
          end_idx: -1
          top_type: broadcast
          top_signame: ast_rom_cfg
          index: -1
          external: true
          conn_type: true
        }
        {
          struct: ast_obs_ctrl
          type: uni
          name: obs_ctrl
          act: rcv
          package: ast_pkg
          inst_name: ast
          width: 1
          default: ""
          end_idx: -1
          top_type: broadcast
          top_signame: ast_obs_ctrl
          index: -1
          external: true
          conn_type: true
        }
      ]
    }
  ]
  inter_module:
  {
    connect:
    {
      ast.obs_ctrl:
      [
        flash_ctrl.obs_ctrl
        otp_ctrl.obs_ctrl
      ]
      ast.ram_1p_cfg:
      [
        i2c0.ram_cfg
        sram_ctrl_main.cfg
        sram_ctrl_ret_aon.cfg
        rv_core_ibex.ram_cfg
      ]
      ast.spi_ram_2p_cfg:
      [
        spi_device.ram_cfg
      ]
      ast.rom_cfg:
      [
        rom_ctrl.rom_cfg
      ]
      alert_handler.crashdump:
      [
        rstmgr_aon.alert_dump
      ]
      alert_handler.esc_rx:
      [
        rv_core_ibex.esc_rx
        lc_ctrl.esc_scrap_state0_rx
        lc_ctrl.esc_scrap_state1_rx
        pwrmgr_aon.esc_rst_rx
      ]
      alert_handler.esc_tx:
      [
        rv_core_ibex.esc_tx
        lc_ctrl.esc_scrap_state0_tx
        lc_ctrl.esc_scrap_state1_tx
        pwrmgr_aon.esc_rst_tx
      ]
      aon_timer_aon.nmi_wdog_timer_bark:
      [
        rv_core_ibex.nmi_wdog
      ]
      csrng.csrng_cmd:
      [
        edn0.csrng_cmd
      ]
      csrng.entropy_src_hw_if:
      [
        entropy_src.entropy_src_hw_if
      ]
      csrng.cs_aes_halt:
      [
        entropy_src.cs_aes_halt
      ]
      flash_ctrl.keymgr:
      [
        keymgr.flash
      ]
      flash_ctrl.otp:
      [
        otp_ctrl.flash_otp_key
      ]
      flash_ctrl.rma_seed:
      [
        lc_ctrl.lc_flash_rma_seed
      ]
      otp_ctrl.sram_otp_key:
      [
        sram_ctrl_main.sram_otp_key
        sram_ctrl_ret_aon.sram_otp_key
        rv_core_ibex.icache_otp_key
      ]
      pwrmgr_aon.pwr_flash:
      [
        flash_ctrl.pwrmgr
      ]
      pwrmgr_aon.pwr_rst:
      [
        rstmgr_aon.pwr
      ]
      pwrmgr_aon.pwr_clk:
      [
        clkmgr_aon.pwr
      ]
      pwrmgr_aon.pwr_otp:
      [
        otp_ctrl.pwr_otp
      ]
      pwrmgr_aon.pwr_lc:
      [
        lc_ctrl.pwr_lc
      ]
      pwrmgr_aon.strap:
      [
        pinmux_aon.strap_en
      ]
      pwrmgr_aon.low_power:
      [
        pinmux_aon.sleep_en
        aon_timer_aon.sleep_mode
      ]
      pwrmgr_aon.fetch_en:
      [
        rv_core_ibex.pwrmgr_cpu_en
      ]
      rom_ctrl.pwrmgr_data:
      [
        pwrmgr_aon.rom_ctrl
      ]
      rom_ctrl.keymgr_data:
      [
        keymgr.rom_digest
      ]
      lc_ctrl.lc_flash_rma_req:
      [
        flash_ctrl.rma_req
      ]
      lc_ctrl.lc_flash_rma_ack:
      [
        flash_ctrl.rma_ack
      ]
      edn0.edn:
      [
        keymgr.edn
        otp_ctrl.edn
        ast.edn
        kmac.entropy
        alert_handler.edn
        rv_core_ibex.edn
      ]
      otp_ctrl.otp_keymgr_key:
      [
        keymgr.otp_key
      ]
      keymgr.kmac_key:
      [
        kmac.keymgr_key
      ]
      kmac.app:
      [
        keymgr.kmac_data
        lc_ctrl.kmac_data
        rom_ctrl.kmac_data
      ]
      kmac.en_masking:
      [
        keymgr.kmac_en_masking
      ]
      clkmgr_aon.idle:
      [
        kmac.idle
      ]
      pinmux_aon.lc_jtag:
      [
        lc_ctrl.jtag
      ]
      pinmux_aon.rv_jtag:
      [
        rv_dm.jtag
      ]
      pinmux_aon.pinmux_hw_debug_en:
      [
        rv_dm.pinmux_hw_debug_en
      ]
      otp_ctrl.otp_lc_data:
      [
        lc_ctrl.otp_lc_data
      ]
      lc_ctrl.lc_otp_program:
      [
        otp_ctrl.lc_otp_program
      ]
      lc_ctrl.lc_otp_vendor_test:
      [
        otp_ctrl.lc_otp_vendor_test
      ]
      lc_ctrl.lc_keymgr_div:
      [
        keymgr.lc_keymgr_div
      ]
      lc_ctrl.strap_en_override:
      [
        pinmux_aon.strap_en_override
      ]
      lc_ctrl.lc_dft_en:
      [
        otp_ctrl.lc_dft_en
        pinmux_aon.lc_dft_en
        ast.lc_dft_en
        pwrmgr_aon.lc_dft_en
        rv_dm.lc_dft_en
      ]
      lc_ctrl.lc_nvm_debug_en:
      [
        flash_ctrl.lc_nvm_debug_en
      ]
      lc_ctrl.lc_hw_debug_en:
      [
        sram_ctrl_main.lc_hw_debug_en
        pinmux_aon.lc_hw_debug_en
        csrng.lc_hw_debug_en
        rv_dm.lc_hw_debug_en
        clkmgr_aon.lc_hw_debug_en
        pwrmgr_aon.lc_hw_debug_en
      ]
      lc_ctrl.lc_cpu_en:
      [
        rv_core_ibex.lc_cpu_en
      ]
      lc_ctrl.lc_keymgr_en:
      [
        keymgr.lc_keymgr_en
      ]
      lc_ctrl.lc_escalate_en:
      [
        kmac.lc_escalate_en
        otp_ctrl.lc_escalate_en
        sram_ctrl_main.lc_escalate_en
        sram_ctrl_ret_aon.lc_escalate_en
        aon_timer_aon.lc_escalate_en
        flash_ctrl.lc_escalate_en
        pinmux_aon.lc_escalate_en
      ]
      lc_ctrl.lc_check_byp_en:
      [
        otp_ctrl.lc_check_byp_en
        pinmux_aon.lc_check_byp_en
      ]
      lc_ctrl.lc_clk_byp_req:
      [
        clkmgr_aon.lc_clk_byp_req
      ]
      lc_ctrl.lc_clk_byp_ack:
      [
        clkmgr_aon.lc_clk_byp_ack
      ]
      lc_ctrl.lc_creator_seed_sw_rw_en:
      [
        otp_ctrl.lc_creator_seed_sw_rw_en
        flash_ctrl.lc_creator_seed_sw_rw_en
      ]
      lc_ctrl.lc_owner_seed_sw_rw_en:
      [
        flash_ctrl.lc_owner_seed_sw_rw_en
      ]
      lc_ctrl.lc_iso_part_sw_rd_en:
      [
        flash_ctrl.lc_iso_part_sw_rd_en
      ]
      lc_ctrl.lc_iso_part_sw_wr_en:
      [
        flash_ctrl.lc_iso_part_sw_wr_en
      ]
      lc_ctrl.lc_seed_hw_rd_en:
      [
        otp_ctrl.lc_seed_hw_rd_en
        flash_ctrl.lc_seed_hw_rd_en
      ]
      rv_plic.msip:
      [
        rv_core_ibex.irq_software
      ]
      rv_plic.irq:
      [
        rv_core_ibex.irq_external
      ]
      rv_dm.debug_req:
      [
        rv_core_ibex.debug_req
      ]
      rv_core_ibex.crash_dump:
      [
        rstmgr_aon.cpu_dump
      ]
      rv_core_ibex.pwrmgr:
      [
        pwrmgr_aon.pwr_cpu
      ]
      spi_device.passthrough:
      [
        spi_host0.passthrough
      ]
      rv_dm.ndmreset_req:
      [
        pwrmgr_aon.ndmreset_req
      ]
      rstmgr_aon.sw_rst_req:
      [
        pwrmgr_aon.sw_rst_req
      ]
      pwrmgr_aon.wakeups:
      [
        pinmux_aon.pin_wkup_req
        pinmux_aon.usb_wkup_req
        aon_timer_aon.wkup_req
      ]
      pwrmgr_aon.rstreqs:
      [
        aon_timer_aon.aon_timer_rst_req
      ]
      main.tl_rv_core_ibex__corei:
      [
        rv_core_ibex.corei_tl_h
      ]
      main.tl_rv_core_ibex__cored:
      [
        rv_core_ibex.cored_tl_h
      ]
      main.tl_rv_dm__sba:
      [
        rv_dm.sba_tl_h
      ]
      rv_dm.regs_tl_d:
      [
        main.tl_rv_dm__regs
      ]
      rv_dm.mem_tl_d:
      [
        main.tl_rv_dm__mem
      ]
      rom_ctrl.rom_tl:
      [
        main.tl_rom_ctrl__rom
      ]
      rom_ctrl.regs_tl:
      [
        main.tl_rom_ctrl__regs
      ]
      main.tl_peri:
      [
        peri.tl_main
      ]
      spi_host0.tl:
      [
        main.tl_spi_host0
      ]
      flash_ctrl.core_tl:
      [
        main.tl_flash_ctrl__core
      ]
      flash_ctrl.prim_tl:
      [
        main.tl_flash_ctrl__prim
      ]
      flash_ctrl.mem_tl:
      [
        main.tl_flash_ctrl__mem
      ]
      kmac.tl:
      [
        main.tl_kmac
      ]
      entropy_src.tl:
      [
        main.tl_entropy_src
      ]
      csrng.tl:
      [
        main.tl_csrng
      ]
      edn0.tl:
      [
        main.tl_edn0
      ]
      rv_plic.tl:
      [
        main.tl_rv_plic
      ]
      keymgr.tl:
      [
        main.tl_keymgr
      ]
      rv_core_ibex.cfg_tl_d:
      [
        main.tl_rv_core_ibex__cfg
      ]
      sram_ctrl_main.regs_tl:
      [
        main.tl_sram_ctrl_main__regs
      ]
      sram_ctrl_main.ram_tl:
      [
        main.tl_sram_ctrl_main__ram
      ]
      ergo_cdc_bridge0.tl:
      [
        peri.tl_ergo_cdc_bridge0
      ]
      ergo_cdc_bridge1.tl:
      [
        peri.tl_ergo_cdc_bridge1
      ]
      ergo_cdc_bridge2.tl:
      [
        peri.tl_ergo_cdc_bridge2
      ]
      ergo_cdc_bridge3.tl:
      [
        peri.tl_ergo_cdc_bridge3
      ]
      ergo_cdc_bridge4.tl:
      [
        peri.tl_ergo_cdc_bridge4
      ]
      ergo_cdc_bridge5.tl:
      [
        peri.tl_ergo_cdc_bridge5
      ]
      ergo_setup_gen0.tl:
      [
        peri.tl_ergo_setup_gen0
      ]
      ergo_setup_gen1.tl:
      [
        peri.tl_ergo_setup_gen1
      ]
      ergo_setup_gen2.tl:
      [
        peri.tl_ergo_setup_gen2
      ]
      ergo_setup_gen3.tl:
      [
        peri.tl_ergo_setup_gen3
      ]
      ergo_setup_gen4.tl:
      [
        peri.tl_ergo_setup_gen4
      ]
      ergo_setup_gen5.tl:
      [
        peri.tl_ergo_setup_gen5
      ]
      ergo_hold_gen0.tl:
      [
        peri.tl_ergo_hold_gen0
      ]
      ergo_hold_gen1.tl:
      [
        peri.tl_ergo_hold_gen1
      ]
      ergo_hold_gen2.tl:
      [
        peri.tl_ergo_hold_gen2
      ]
      ergo_hold_gen3.tl:
      [
        peri.tl_ergo_hold_gen3
      ]
      ergo_hold_gen4.tl:
      [
        peri.tl_ergo_hold_gen4
      ]
      ergo_cdc_hazard_gen0.tl:
      [
        peri.tl_ergo_cdc_hazard_gen0
      ]
      ergo_cdc_hazard_gen1.tl:
      [
        peri.tl_ergo_cdc_hazard_gen1
      ]
      ergo_cdc_hazard_gen2.tl:
      [
        peri.tl_ergo_cdc_hazard_gen2
      ]
      ergo_cdc_hazard_gen3.tl:
      [
        peri.tl_ergo_cdc_hazard_gen3
      ]
      ergo_cdc_hazard_gen4.tl:
      [
        peri.tl_ergo_cdc_hazard_gen4
      ]
      ergo_cdc_bridge6.tl:
      [
        peri.tl_ergo_cdc_bridge6
      ]
      ergo_cdc_bridge7.tl:
      [
        peri.tl_ergo_cdc_bridge7
      ]
      ergo_cdc_bridge8.tl:
      [
        peri.tl_ergo_cdc_bridge8
      ]
      ergo_setup_gen6.tl:
      [
        peri.tl_ergo_setup_gen6
      ]
      ergo_setup_gen7.tl:
      [
        peri.tl_ergo_setup_gen7
      ]
      ergo_setup_gen8.tl:
      [
        peri.tl_ergo_setup_gen8
      ]
      ergo_hold_gen5.tl:
      [
        peri.tl_ergo_hold_gen5
      ]
      ergo_hold_gen6.tl:
      [
        peri.tl_ergo_hold_gen6
      ]
      ergo_cdc_hazard_gen5.tl:
      [
        peri.tl_ergo_cdc_hazard_gen5
      ]
      ergo_cdc_hazard_gen6.tl:
      [
        peri.tl_ergo_cdc_hazard_gen6
      ]
      uart0.tl:
      [
        peri.tl_uart0
      ]
      i2c0.tl:
      [
        peri.tl_i2c0
      ]
      gpio.tl:
      [
        peri.tl_gpio
      ]
      spi_device.tl:
      [
        peri.tl_spi_device
      ]
      rv_timer.tl:
      [
        peri.tl_rv_timer
      ]
      pwrmgr_aon.tl:
      [
        peri.tl_pwrmgr_aon
      ]
      rstmgr_aon.tl:
      [
        peri.tl_rstmgr_aon
      ]
      clkmgr_aon.tl:
      [
        peri.tl_clkmgr_aon
      ]
      pinmux_aon.tl:
      [
        peri.tl_pinmux_aon
      ]
      otp_ctrl.core_tl:
      [
        peri.tl_otp_ctrl__core
      ]
      otp_ctrl.prim_tl:
      [
        peri.tl_otp_ctrl__prim
      ]
      lc_ctrl.tl:
      [
        peri.tl_lc_ctrl
      ]
      alert_handler.tl:
      [
        peri.tl_alert_handler
      ]
      sram_ctrl_ret_aon.regs_tl:
      [
        peri.tl_sram_ctrl_ret_aon__regs
      ]
      sram_ctrl_ret_aon.ram_tl:
      [
        peri.tl_sram_ctrl_ret_aon__ram
      ]
      aon_timer_aon.tl:
      [
        peri.tl_aon_timer_aon
      ]
    }
    top:
    [
      clkmgr_aon.clocks
      clkmgr_aon.cg_en
      rstmgr_aon.resets
      rstmgr_aon.rst_en
      rv_core_ibex.irq_timer
      rv_core_ibex.hart_id
      rv_core_ibex.boot_addr
      pinmux_aon.dft_jtag
      otp_ctrl.otp_broadcast
      csrng.otp_en_csrng_sw_app_read
      lc_ctrl.otp_device_id
      lc_ctrl.otp_manuf_state
      keymgr.otp_device_id
      sram_ctrl_main.otp_en_sram_ifetch
      rv_dm.otp_dis_rv_dm_late_debug
    ]
    external:
    {
      ast.edn: ""
      ast.lc_dft_en: ""
      ast.obs_ctrl: obs_ctrl
      ast.ram_1p_cfg: ram_1p_cfg
      ast.spi_ram_2p_cfg: spi_ram_2p_cfg
      ast.rom_cfg: rom_cfg
      clkmgr_aon.jitter_en: clk_main_jitter_en
      clkmgr_aon.io_clk_byp_req: io_clk_byp_req
      clkmgr_aon.io_clk_byp_ack: io_clk_byp_ack
      clkmgr_aon.all_clk_byp_req: all_clk_byp_req
      clkmgr_aon.all_clk_byp_ack: all_clk_byp_ack
      clkmgr_aon.hi_speed_sel: hi_speed_sel
      clkmgr_aon.div_step_down_req: div_step_down_req
      clkmgr_aon.calib_rdy: calib_rdy
      flash_ctrl.flash_bist_enable: flash_bist_enable
      flash_ctrl.flash_power_down_h: flash_power_down_h
      flash_ctrl.flash_power_ready_h: flash_power_ready_h
      flash_ctrl.flash_test_mode_a: flash_test_mode_a
      flash_ctrl.flash_test_voltage_h: flash_test_voltage_h
      flash_ctrl.fla_obs: flash_obs
      entropy_src.entropy_src_rng: es_rng
      entropy_src.rng_fips: es_rng_fips
      peri.tl_ast: ast_tl
      pinmux_aon.dft_strap_test: dft_strap_test
      pinmux_aon.dft_hold_tap_sel: dft_hold_tap_sel
      pinmux_aon.usb_dppullup_en: usb_dp_pullup_en
      pinmux_aon.usb_dnpullup_en: usb_dn_pullup_en
      pwrmgr_aon.pwr_ast: pwrmgr_ast
      otp_ctrl.otp_ast_pwr_seq: ""
      otp_ctrl.otp_ast_pwr_seq_h: ""
      otp_ctrl.otp_ext_voltage_h: otp_ext_voltage_h
      otp_ctrl.otp_obs: otp_obs
      rstmgr_aon.por_n: por_n
      rv_core_ibex.fpga_info: fpga_info
      spi_device.sck_monitor: sck_monitor
    }
  }
  xbar:
  [
    {
      name: main
      clock_srcs:
      {
        clk_main_i: main
        clk_fixed_i: io_div4
        clk_spi_host0_i: io
      }
      clock_group: infra
      reset: rst_main_ni
      reset_connections:
      {
        rst_main_ni:
        {
          name: lc
          domain: "0"
        }
        rst_fixed_ni:
        {
          name: lc_io_div4
          domain: "0"
        }
        rst_spi_host0_ni:
        {
          name: lc_io
          domain: "0"
        }
      }
      clock_connections:
      {
        clk_main_i: clkmgr_aon_clocks.clk_main_infra
        clk_fixed_i: clkmgr_aon_clocks.clk_io_div4_infra
        clk_spi_host0_i: clkmgr_aon_clocks.clk_io_infra
      }
      domain:
      [
        "0"
      ]
      connections:
      {
        rv_core_ibex.corei:
        [
          rom_ctrl.rom
          rv_dm.mem
          sram_ctrl_main.ram
          flash_ctrl.mem
        ]
        rv_core_ibex.cored:
        [
          rom_ctrl.rom
          rom_ctrl.regs
          rv_dm.mem
          rv_dm.regs
          sram_ctrl_main.ram
          peri
          spi_host0
          flash_ctrl.core
          flash_ctrl.prim
          flash_ctrl.mem
          entropy_src
          csrng
          edn0
          rv_plic
          keymgr
          kmac
          sram_ctrl_main.regs
          rv_core_ibex.cfg
        ]
        rv_dm.sba:
        [
          rom_ctrl.rom
          rom_ctrl.regs
          rv_dm.mem
          rv_dm.regs
          sram_ctrl_main.ram
          peri
          spi_host0
          flash_ctrl.core
          flash_ctrl.prim
          flash_ctrl.mem
          entropy_src
          csrng
          edn0
          rv_plic
          keymgr
          kmac
          sram_ctrl_main.regs
          rv_core_ibex.cfg
        ]
      }
      nodes:
      [
        {
          name: rv_core_ibex.corei
          type: host
          clock: clk_main_i
          reset: rst_main_ni
          pipeline: false
          xbar: false
          stub: false
          inst_type: ""
          req_fifo_pass: true
          rsp_fifo_pass: true
        }
        {
          name: rv_core_ibex.cored
          type: host
          clock: clk_main_i
          reset: rst_main_ni
          pipeline: false
          xbar: false
          stub: false
          inst_type: ""
          req_fifo_pass: true
          rsp_fifo_pass: true
        }
        {
          name: rv_dm.sba
          type: host
          clock: clk_main_i
          reset: rst_main_ni
          req_fifo_pass: false
          rsp_fifo_pass: false
          xbar: false
          stub: false
          inst_type: ""
          pipeline: true
        }
        {
          name: rv_dm.regs
          type: device
          clock: clk_main_i
          reset: rst_main_ni
          req_fifo_pass: false
          rsp_fifo_pass: false
          inst_type: rv_dm
          addr_range:
          [
            {
              base_addr: 0x41200000
              size_byte: 0x10
            }
          ]
          xbar: false
          stub: false
          pipeline: true
        }
        {
          name: rv_dm.mem
          type: device
          clock: clk_main_i
          reset: rst_main_ni
          req_fifo_pass: false
          rsp_fifo_pass: false
          inst_type: rv_dm
          addr_range:
          [
            {
              base_addr: 0x10000
              size_byte: 0x1000
            }
          ]
          xbar: false
          stub: false
          pipeline: true
        }
        {
          name: rom_ctrl.rom
          type: device
          clock: clk_main_i
          reset: rst_main_ni
          req_fifo_pass: true
          rsp_fifo_pass: false
          inst_type: rom_ctrl
          addr_range:
          [
            {
              base_addr: 0x8000
              size_byte: 0x8000
            }
          ]
          xbar: false
          stub: false
          pipeline: true
        }
        {
          name: rom_ctrl.regs
          type: device
          clock: clk_main_i
          reset: rst_main_ni
          req_fifo_pass: false
          rsp_fifo_pass: false
          inst_type: rom_ctrl
          addr_range:
          [
            {
              base_addr: 0x411e0000
              size_byte: 0x80
            }
          ]
          xbar: false
          stub: false
          pipeline: true
        }
        {
          name: peri
          type: device
          clock: clk_fixed_i
          reset: rst_fixed_ni
          req_fifo_pass: false
          rsp_fifo_pass: false
          xbar: true
          stub: false
          pipeline: true
          addr_range:
          [
            {
              base_addr: 0x40000000
              size_byte: 0x2e0004
            }
            {
              base_addr: 0x40400000
              size_byte: 0x201000
            }
          ]
        }
        {
          name: spi_host0
          type: device
          clock: clk_spi_host0_i
          reset: rst_spi_host0_ni
          req_fifo_pass: false
          rsp_fifo_pass: false
          inst_type: spi_host
          addr_range:
          [
            {
              base_addr: 0x40300000
              size_byte: 0x40
            }
          ]
          xbar: false
          stub: false
          pipeline: true
        }
        {
          name: flash_ctrl.core
          type: device
          clock: clk_main_i
          reset: rst_main_ni
          req_fifo_pass: false
          rsp_fifo_pass: false
          inst_type: flash_ctrl
          addr_range:
          [
            {
              base_addr: 0x41000000
              size_byte: 0x200
            }
          ]
          xbar: false
          stub: false
          pipeline: true
        }
        {
          name: flash_ctrl.prim
          type: device
          clock: clk_main_i
          reset: rst_main_ni
          req_fifo_pass: false
          rsp_fifo_pass: false
          inst_type: flash_ctrl
          addr_range:
          [
            {
              base_addr: 0x41008000
              size_byte: 0x80
            }
          ]
          xbar: false
          stub: false
          pipeline: true
        }
        {
          name: flash_ctrl.mem
          type: device
          clock: clk_main_i
          reset: rst_main_ni
          req_fifo_pass: false
          rsp_fifo_pass: false
          inst_type: flash_ctrl
          addr_range:
          [
            {
              base_addr: 0x20000000
              size_byte: 0x100000
            }
          ]
          xbar: false
          stub: false
          pipeline: true
        }
        {
          name: kmac
          type: device
          clock: clk_main_i
          reset: rst_main_ni
          req_fifo_pass: false
          rsp_fifo_pass: false
          inst_type: kmac
          addr_range:
          [
            {
              base_addr: 0x41120000
              size_byte: 0x1000
            }
          ]
          xbar: false
          stub: false
          pipeline: true
        }
        {
          name: entropy_src
          type: device
          clock: clk_main_i
          reset: rst_main_ni
          req_fifo_pass: false
          rsp_fifo_pass: false
          inst_type: entropy_src
          addr_range:
          [
            {
              base_addr: 0x41160000
              size_byte: 0x100
            }
          ]
          xbar: false
          stub: false
          pipeline: true
        }
        {
          name: csrng
          type: device
          clock: clk_main_i
          reset: rst_main_ni
          req_fifo_pass: false
          rsp_fifo_pass: false
          inst_type: csrng
          addr_range:
          [
            {
              base_addr: 0x41150000
              size_byte: 0x80
            }
          ]
          xbar: false
          stub: false
          pipeline: true
        }
        {
          name: edn0
          type: device
          clock: clk_main_i
          reset: rst_main_ni
          req_fifo_pass: false
          rsp_fifo_pass: false
          inst_type: edn
          addr_range:
          [
            {
              base_addr: 0x41170000
              size_byte: 0x80
            }
          ]
          xbar: false
          stub: false
          pipeline: true
        }
        {
          name: rv_plic
          type: device
          clock: clk_main_i
          reset: rst_main_ni
          inst_type: rv_plic
          req_fifo_pass: false
          rsp_fifo_pass: false
          addr_range:
          [
            {
              base_addr: 0x48000000
              size_byte: 0x8000000
            }
          ]
          xbar: false
          stub: false
          pipeline: true
        }
        {
          name: keymgr
          type: device
          clock: clk_main_i
          reset: rst_main_ni
          req_fifo_pass: false
          rsp_fifo_pass: false
          inst_type: keymgr
          addr_range:
          [
            {
              base_addr: 0x41140000
              size_byte: 0x100
            }
          ]
          xbar: false
          stub: false
          pipeline: true
        }
        {
          name: rv_core_ibex.cfg
          type: device
          clock: clk_main_i
          reset: rst_main_ni
          req_fifo_pass: false
          rsp_fifo_pass: false
          inst_type: rv_core_ibex
          addr_range:
          [
            {
              base_addr: 0x411f0000
              size_byte: 0x100
            }
          ]
          xbar: false
          stub: false
          pipeline: true
        }
        {
          name: sram_ctrl_main.regs
          type: device
          clock: clk_main_i
          reset: rst_main_ni
          req_fifo_pass: false
          rsp_fifo_pass: false
          inst_type: sram_ctrl
          addr_range:
          [
            {
              base_addr: 0x411c0000
              size_byte: 0x40
            }
          ]
          xbar: false
          stub: false
          pipeline: true
        }
        {
          name: sram_ctrl_main.ram
          type: device
          clock: clk_main_i
          reset: rst_main_ni
          pipeline: false
          inst_type: sram_ctrl
          addr_range:
          [
            {
              base_addr: 0x10000000
              size_byte: 0x20000
            }
          ]
          xbar: false
          stub: false
          req_fifo_pass: true
        }
      ]
      clock: clk_main_i
      type: xbar
      inter_signal_list:
      [
        {
          name: tl_rv_core_ibex__corei
          struct: tl
          package: tlul_pkg
          type: req_rsp
          act: rsp
          width: 1
          inst_name: main
          default: ""
          end_idx: -1
          top_signame: main_tl_rv_core_ibex__corei
          index: -1
        }
        {
          name: tl_rv_core_ibex__cored
          struct: tl
          package: tlul_pkg
          type: req_rsp
          act: rsp
          width: 1
          inst_name: main
          default: ""
          end_idx: -1
          top_signame: main_tl_rv_core_ibex__cored
          index: -1
        }
        {
          name: tl_rv_dm__sba
          struct: tl
          package: tlul_pkg
          type: req_rsp
          act: rsp
          width: 1
          inst_name: main
          default: ""
          end_idx: -1
          top_signame: main_tl_rv_dm__sba
          index: -1
        }
        {
          name: tl_rv_dm__regs
          struct: tl
          package: tlul_pkg
          type: req_rsp
          act: req
          width: 1
          inst_name: main
          default: ""
          top_signame: rv_dm_regs_tl_d
          index: -1
        }
        {
          name: tl_rv_dm__mem
          struct: tl
          package: tlul_pkg
          type: req_rsp
          act: req
          width: 1
          inst_name: main
          default: ""
          top_signame: rv_dm_mem_tl_d
          index: -1
        }
        {
          name: tl_rom_ctrl__rom
          struct: tl
          package: tlul_pkg
          type: req_rsp
          act: req
          width: 1
          inst_name: main
          default: ""
          top_signame: rom_ctrl_rom_tl
          index: -1
        }
        {
          name: tl_rom_ctrl__regs
          struct: tl
          package: tlul_pkg
          type: req_rsp
          act: req
          width: 1
          inst_name: main
          default: ""
          top_signame: rom_ctrl_regs_tl
          index: -1
        }
        {
          name: tl_peri
          struct: tl
          package: tlul_pkg
          type: req_rsp
          act: req
          width: 1
          inst_name: main
          default: ""
          end_idx: -1
          top_signame: main_tl_peri
          index: -1
        }
        {
          name: tl_spi_host0
          struct: tl
          package: tlul_pkg
          type: req_rsp
          act: req
          width: 1
          inst_name: main
          default: ""
          top_signame: spi_host0_tl
          index: -1
        }
        {
          name: tl_flash_ctrl__core
          struct: tl
          package: tlul_pkg
          type: req_rsp
          act: req
          width: 1
          inst_name: main
          default: ""
          top_signame: flash_ctrl_core_tl
          index: -1
        }
        {
          name: tl_flash_ctrl__prim
          struct: tl
          package: tlul_pkg
          type: req_rsp
          act: req
          width: 1
          inst_name: main
          default: ""
          top_signame: flash_ctrl_prim_tl
          index: -1
        }
        {
          name: tl_flash_ctrl__mem
          struct: tl
          package: tlul_pkg
          type: req_rsp
          act: req
          width: 1
          inst_name: main
          default: ""
          top_signame: flash_ctrl_mem_tl
          index: -1
        }
        {
          name: tl_kmac
          struct: tl
          package: tlul_pkg
          type: req_rsp
          act: req
          width: 1
          inst_name: main
          default: ""
          top_signame: kmac_tl
          index: -1
        }
        {
          name: tl_entropy_src
          struct: tl
          package: tlul_pkg
          type: req_rsp
          act: req
          width: 1
          inst_name: main
          default: ""
          top_signame: entropy_src_tl
          index: -1
        }
        {
          name: tl_csrng
          struct: tl
          package: tlul_pkg
          type: req_rsp
          act: req
          width: 1
          inst_name: main
          default: ""
          top_signame: csrng_tl
          index: -1
        }
        {
          name: tl_edn0
          struct: tl
          package: tlul_pkg
          type: req_rsp
          act: req
          width: 1
          inst_name: main
          default: ""
          top_signame: edn0_tl
          index: -1
        }
        {
          name: tl_rv_plic
          struct: tl
          package: tlul_pkg
          type: req_rsp
          act: req
          width: 1
          inst_name: main
          default: ""
          top_signame: rv_plic_tl
          index: -1
        }
        {
          name: tl_keymgr
          struct: tl
          package: tlul_pkg
          type: req_rsp
          act: req
          width: 1
          inst_name: main
          default: ""
          top_signame: keymgr_tl
          index: -1
        }
        {
          name: tl_rv_core_ibex__cfg
          struct: tl
          package: tlul_pkg
          type: req_rsp
          act: req
          width: 1
          inst_name: main
          default: ""
          top_signame: rv_core_ibex_cfg_tl_d
          index: -1
        }
        {
          name: tl_sram_ctrl_main__regs
          struct: tl
          package: tlul_pkg
          type: req_rsp
          act: req
          width: 1
          inst_name: main
          default: ""
          top_signame: sram_ctrl_main_regs_tl
          index: -1
        }
        {
          name: tl_sram_ctrl_main__ram
          struct: tl
          package: tlul_pkg
          type: req_rsp
          act: req
          width: 1
          inst_name: main
          default: ""
          top_signame: sram_ctrl_main_ram_tl
          index: -1
        }
      ]
    }
    {
      name: peri
      clock_srcs:
      {
        clk_peri_i: io_div4
      }
      clock_group: infra
      reset: rst_peri_ni
      reset_connections:
      {
        rst_peri_ni:
        {
          name: lc_io_div4
          domain: "0"
        }
      }
      clock_connections:
      {
        clk_peri_i: clkmgr_aon_clocks.clk_io_div4_infra
      }
      domain:
      [
        "0"
      ]
      connections:
      {
        main:
        [
          ergo_cdc_bridge0
          ergo_cdc_bridge1
          ergo_cdc_bridge2
          ergo_cdc_bridge3
          ergo_cdc_bridge4
          ergo_cdc_bridge5
          ergo_setup_gen0
          ergo_setup_gen1
          ergo_setup_gen2
          ergo_setup_gen3
          ergo_setup_gen4
          ergo_setup_gen5
          ergo_hold_gen0
          ergo_hold_gen1
          ergo_hold_gen2
          ergo_hold_gen3
          ergo_hold_gen4
          ergo_cdc_hazard_gen0
          ergo_cdc_hazard_gen1
          ergo_cdc_hazard_gen2
          ergo_cdc_hazard_gen3
          ergo_cdc_hazard_gen4
          ergo_cdc_bridge6
          ergo_cdc_bridge7
          ergo_cdc_bridge8
          ergo_setup_gen6
          ergo_setup_gen7
          ergo_setup_gen8
          ergo_hold_gen5
          ergo_hold_gen6
          ergo_cdc_hazard_gen5
          ergo_cdc_hazard_gen6
          uart0
          i2c0
          gpio
          spi_device
          rv_timer
          pwrmgr_aon
          rstmgr_aon
          clkmgr_aon
          pinmux_aon
          otp_ctrl.core
          otp_ctrl.prim
          lc_ctrl
          alert_handler
          ast
          sram_ctrl_ret_aon.ram
          sram_ctrl_ret_aon.regs
          aon_timer_aon
        ]
      }
      nodes:
      [
        {
          name: main
          type: host
          clock: clk_peri_i
          reset: rst_peri_ni
          xbar: true
          pipeline: false
          stub: false
          inst_type: ""
          req_fifo_pass: true
          rsp_fifo_pass: true
        }
        {
          name: ergo_cdc_bridge0
          type: device
          clock: clk_peri_i
          reset: rst_peri_ni
          pipeline: false
          inst_type: ergo_cdc_bridge
          addr_range:
          [
            {
              base_addr: 0x40060000
              size_byte: 0x10
            }
          ]
          xbar: false
          stub: false
          req_fifo_pass: true
        }
        {
          name: ergo_cdc_bridge1
          type: device
          clock: clk_peri_i
          reset: rst_peri_ni
          pipeline: false
          inst_type: ergo_cdc_bridge
          addr_range:
          [
            {
              base_addr: 0x40070000
              size_byte: 0x10
            }
          ]
          xbar: false
          stub: false
          req_fifo_pass: true
        }
        {
          name: ergo_cdc_bridge2
          type: device
          clock: clk_peri_i
          reset: rst_peri_ni
          pipeline: false
          inst_type: ergo_cdc_bridge
          addr_range:
          [
            {
              base_addr: 0x400b0000
              size_byte: 0x10
            }
          ]
          xbar: false
          stub: false
          req_fifo_pass: true
        }
        {
          name: ergo_cdc_bridge3
          type: device
          clock: clk_peri_i
          reset: rst_peri_ni
          pipeline: false
          inst_type: ergo_cdc_bridge
          addr_range:
          [
            {
              base_addr: 0x400c0000
              size_byte: 0x10
            }
          ]
          xbar: false
          stub: false
          req_fifo_pass: true
        }
        {
          name: ergo_cdc_bridge4
          type: device
          clock: clk_peri_i
          reset: rst_peri_ni
          pipeline: false
          inst_type: ergo_cdc_bridge
          addr_range:
          [
            {
              base_addr: 0x400d0000
              size_byte: 0x10
            }
          ]
          xbar: false
          stub: false
          req_fifo_pass: true
        }
        {
          name: ergo_cdc_bridge5
          type: device
          clock: clk_peri_i
          reset: rst_peri_ni
          pipeline: false
          inst_type: ergo_cdc_bridge
          addr_range:
          [
            {
              base_addr: 0x40110000
              size_byte: 0x10
            }
          ]
          xbar: false
          stub: false
          req_fifo_pass: true
        }
        {
          name: ergo_setup_gen0
          type: device
          clock: clk_peri_i
          reset: rst_peri_ni
          pipeline: false
          inst_type: ergo_setup_gen
          addr_range:
          [
            {
              base_addr: 0x40120000
              size_byte: 0x8
            }
          ]
          xbar: false
          stub: false
          req_fifo_pass: true
        }
        {
          name: ergo_setup_gen1
          type: device
          clock: clk_peri_i
          reset: rst_peri_ni
          pipeline: false
          inst_type: ergo_setup_gen
          addr_range:
          [
            {
              base_addr: 0x40160000
              size_byte: 0x8
            }
          ]
          xbar: false
          stub: false
          req_fifo_pass: true
        }
        {
          name: ergo_setup_gen2
          type: device
          clock: clk_peri_i
          reset: rst_peri_ni
          pipeline: false
          inst_type: ergo_setup_gen
          addr_range:
          [
            {
              base_addr: 0x40170000
              size_byte: 0x8
            }
          ]
          xbar: false
          stub: false
          req_fifo_pass: true
        }
        {
          name: ergo_setup_gen3
          type: device
          clock: clk_peri_i
          reset: rst_peri_ni
          pipeline: false
          inst_type: ergo_setup_gen
          addr_range:
          [
            {
              base_addr: 0x40180000
              size_byte: 0x8
            }
          ]
          xbar: false
          stub: false
          req_fifo_pass: true
        }
        {
          name: ergo_setup_gen4
          type: device
          clock: clk_peri_i
          reset: rst_peri_ni
          pipeline: false
          inst_type: ergo_setup_gen
          addr_range:
          [
            {
              base_addr: 0x40190000
              size_byte: 0x8
            }
          ]
          xbar: false
          stub: false
          req_fifo_pass: true
        }
        {
          name: ergo_setup_gen5
          type: device
          clock: clk_peri_i
          reset: rst_peri_ni
          pipeline: false
          inst_type: ergo_setup_gen
          addr_range:
          [
            {
              base_addr: 0x401a0000
              size_byte: 0x8
            }
          ]
          xbar: false
          stub: false
          req_fifo_pass: true
        }
        {
          name: ergo_hold_gen0
          type: device
          clock: clk_peri_i
          reset: rst_peri_ni
          pipeline: false
          inst_type: ergo_hold_gen
          addr_range:
          [
            {
              base_addr: 0x401b0000
              size_byte: 0x8
            }
          ]
          xbar: false
          stub: false
          req_fifo_pass: true
        }
        {
          name: ergo_hold_gen1
          type: device
          clock: clk_peri_i
          reset: rst_peri_ni
          pipeline: false
          inst_type: ergo_hold_gen
          addr_range:
          [
            {
              base_addr: 0x401c0000
              size_byte: 0x8
            }
          ]
          xbar: false
          stub: false
          req_fifo_pass: true
        }
        {
          name: ergo_hold_gen2
          type: device
          clock: clk_peri_i
          reset: rst_peri_ni
          pipeline: false
          inst_type: ergo_hold_gen
          addr_range:
          [
            {
              base_addr: 0x401d0000
              size_byte: 0x8
            }
          ]
          xbar: false
          stub: false
          req_fifo_pass: true
        }
        {
          name: ergo_hold_gen3
          type: device
          clock: clk_peri_i
          reset: rst_peri_ni
          pipeline: false
          inst_type: ergo_hold_gen
          addr_range:
          [
            {
              base_addr: 0x401e0000
              size_byte: 0x8
            }
          ]
          xbar: false
          stub: false
          req_fifo_pass: true
        }
        {
          name: ergo_hold_gen4
          type: device
          clock: clk_peri_i
          reset: rst_peri_ni
          pipeline: false
          inst_type: ergo_hold_gen
          addr_range:
          [
            {
              base_addr: 0x401f0000
              size_byte: 0x8
            }
          ]
          xbar: false
          stub: false
          req_fifo_pass: true
        }
        {
          name: ergo_cdc_hazard_gen0
          type: device
          clock: clk_peri_i
          reset: rst_peri_ni
          pipeline: false
          inst_type: ergo_cdc_hazard_gen
          addr_range:
          [
            {
              base_addr: 0x40200000
              size_byte: 0x4
            }
          ]
          xbar: false
          stub: false
          req_fifo_pass: true
        }
        {
          name: ergo_cdc_hazard_gen1
          type: device
          clock: clk_peri_i
          reset: rst_peri_ni
          pipeline: false
          inst_type: ergo_cdc_hazard_gen
          addr_range:
          [
            {
              base_addr: 0x40210000
              size_byte: 0x4
            }
          ]
          xbar: false
          stub: false
          req_fifo_pass: true
        }
        {
          name: ergo_cdc_hazard_gen2
          type: device
          clock: clk_peri_i
          reset: rst_peri_ni
          pipeline: false
          inst_type: ergo_cdc_hazard_gen
          addr_range:
          [
            {
              base_addr: 0x40220000
              size_byte: 0x4
            }
          ]
          xbar: false
          stub: false
          req_fifo_pass: true
        }
        {
          name: ergo_cdc_hazard_gen3
          type: device
          clock: clk_peri_i
          reset: rst_peri_ni
          pipeline: false
          inst_type: ergo_cdc_hazard_gen
          addr_range:
          [
            {
              base_addr: 0x40230000
              size_byte: 0x4
            }
          ]
          xbar: false
          stub: false
          req_fifo_pass: true
        }
        {
          name: ergo_cdc_hazard_gen4
          type: device
          clock: clk_peri_i
          reset: rst_peri_ni
          pipeline: false
          inst_type: ergo_cdc_hazard_gen
          addr_range:
          [
            {
              base_addr: 0x40240000
              size_byte: 0x4
            }
          ]
          xbar: false
          stub: false
          req_fifo_pass: true
        }
        {
          name: ergo_cdc_bridge6
          type: device
          clock: clk_peri_i
          reset: rst_peri_ni
          pipeline: false
          inst_type: ergo_cdc_bridge
          addr_range:
          [
            {
              base_addr: 0x40250000
              size_byte: 0x10
            }
          ]
          xbar: false
          stub: false
          req_fifo_pass: true
        }
        {
          name: ergo_cdc_bridge7
          type: device
          clock: clk_peri_i
          reset: rst_peri_ni
          pipeline: false
          inst_type: ergo_cdc_bridge
          addr_range:
          [
            {
              base_addr: 0x40260000
              size_byte: 0x10
            }
          ]
          xbar: false
          stub: false
          req_fifo_pass: true
        }
        {
          name: ergo_cdc_bridge8
          type: device
          clock: clk_peri_i
          reset: rst_peri_ni
          pipeline: false
          inst_type: ergo_cdc_bridge
          addr_range:
          [
            {
              base_addr: 0x40270000
              size_byte: 0x10
            }
          ]
          xbar: false
          stub: false
          req_fifo_pass: true
        }
        {
          name: ergo_setup_gen6
          type: device
          clock: clk_peri_i
          reset: rst_peri_ni
          pipeline: false
          inst_type: ergo_setup_gen
          addr_range:
          [
            {
              base_addr: 0x40280000
              size_byte: 0x8
            }
          ]
          xbar: false
          stub: false
          req_fifo_pass: true
        }
        {
          name: ergo_setup_gen7
          type: device
          clock: clk_peri_i
          reset: rst_peri_ni
          pipeline: false
          inst_type: ergo_setup_gen
          addr_range:
          [
            {
              base_addr: 0x40290000
              size_byte: 0x8
            }
          ]
          xbar: false
          stub: false
          req_fifo_pass: true
        }
        {
          name: ergo_setup_gen8
          type: device
          clock: clk_peri_i
          reset: rst_peri_ni
          pipeline: false
          inst_type: ergo_setup_gen
          addr_range:
          [
            {
              base_addr: 0x402a0000
              size_byte: 0x8
            }
          ]
          xbar: false
          stub: false
          req_fifo_pass: true
        }
        {
          name: ergo_hold_gen5
          type: device
          clock: clk_peri_i
          reset: rst_peri_ni
          pipeline: false
          inst_type: ergo_hold_gen
          addr_range:
          [
            {
              base_addr: 0x402b0000
              size_byte: 0x8
            }
          ]
          xbar: false
          stub: false
          req_fifo_pass: true
        }
        {
          name: ergo_hold_gen6
          type: device
          clock: clk_peri_i
          reset: rst_peri_ni
          pipeline: false
          inst_type: ergo_hold_gen
          addr_range:
          [
            {
              base_addr: 0x402c0000
              size_byte: 0x8
            }
          ]
          xbar: false
          stub: false
          req_fifo_pass: true
        }
        {
          name: ergo_cdc_hazard_gen5
          type: device
          clock: clk_peri_i
          reset: rst_peri_ni
          pipeline: false
          inst_type: ergo_cdc_hazard_gen
          addr_range:
          [
            {
              base_addr: 0x402d0000
              size_byte: 0x4
            }
          ]
          xbar: false
          stub: false
          req_fifo_pass: true
        }
        {
          name: ergo_cdc_hazard_gen6
          type: device
          clock: clk_peri_i
          reset: rst_peri_ni
          pipeline: false
          inst_type: ergo_cdc_hazard_gen
          addr_range:
          [
            {
              base_addr: 0x402e0000
              size_byte: 0x4
            }
          ]
          xbar: false
          stub: false
          req_fifo_pass: true
        }
        {
          name: uart0
          type: device
          clock: clk_peri_i
          reset: rst_peri_ni
          pipeline: false
          inst_type: uart
          addr_range:
          [
            {
              base_addr: 0x40000000
              size_byte: 0x40
            }
          ]
          xbar: false
          stub: false
          req_fifo_pass: true
        }
        {
          name: i2c0
          type: device
          clock: clk_peri_i
          reset: rst_peri_ni
          pipeline: false
          inst_type: i2c
          addr_range:
          [
            {
              base_addr: 0x40080000
              size_byte: 0x80
            }
          ]
          xbar: false
          stub: false
          req_fifo_pass: true
        }
        {
          name: gpio
          type: device
          clock: clk_peri_i
          reset: rst_peri_ni
          pipeline: false
          inst_type: gpio
          addr_range:
          [
            {
              base_addr: 0x40040000
              size_byte: 0x40
            }
          ]
          xbar: false
          stub: false
          req_fifo_pass: true
        }
        {
          name: spi_device
          type: device
          clock: clk_peri_i
          reset: rst_peri_ni
          pipeline: false
          inst_type: spi_device
          addr_range:
          [
            {
              base_addr: 0x40050000
              size_byte: 0x2000
            }
          ]
          xbar: false
          stub: false
          req_fifo_pass: true
        }
        {
          name: rv_timer
          type: device
          clock: clk_peri_i
          reset: rst_peri_ni
          pipeline: false
          inst_type: rv_timer
          addr_range:
          [
            {
              base_addr: 0x40100000
              size_byte: 0x200
            }
          ]
          xbar: false
          stub: false
          req_fifo_pass: true
        }
        {
          name: pwrmgr_aon
          type: device
          clock: clk_peri_i
          reset: rst_peri_ni
          pipeline: false
          inst_type: pwrmgr
          addr_range:
          [
            {
              base_addr: 0x40400000
              size_byte: 0x80
            }
          ]
          xbar: false
          stub: false
          req_fifo_pass: true
        }
        {
          name: rstmgr_aon
          type: device
          clock: clk_peri_i
          reset: rst_peri_ni
          pipeline: false
          inst_type: rstmgr
          addr_range:
          [
            {
              base_addr: 0x40410000
              size_byte: 0x80
            }
          ]
          xbar: false
          stub: false
          req_fifo_pass: true
        }
        {
          name: clkmgr_aon
          type: device
          clock: clk_peri_i
          reset: rst_peri_ni
          pipeline: false
          inst_type: clkmgr
          addr_range:
          [
            {
              base_addr: 0x40420000
              size_byte: 0x80
            }
          ]
          xbar: false
          stub: false
          req_fifo_pass: true
        }
        {
          name: pinmux_aon
          type: device
          clock: clk_peri_i
          reset: rst_peri_ni
          pipeline: false
          inst_type: pinmux
          addr_range:
          [
            {
              base_addr: 0x40460000
              size_byte: 0x800
            }
          ]
          xbar: false
          stub: false
          req_fifo_pass: true
        }
        {
          name: otp_ctrl.core
          type: device
          clock: clk_peri_i
          reset: rst_peri_ni
          pipeline: false
          inst_type: otp_ctrl
          addr_range:
          [
            {
              base_addr: 0x40130000
              size_byte: 0x1000
            }
          ]
          xbar: false
          stub: false
          req_fifo_pass: true
        }
        {
          name: otp_ctrl.prim
          type: device
          clock: clk_peri_i
          reset: rst_peri_ni
          pipeline: false
          inst_type: otp_ctrl
          addr_range:
          [
            {
              base_addr: 0x40138000
              size_byte: 0x20
            }
          ]
          xbar: false
          stub: false
          req_fifo_pass: true
        }
        {
          name: lc_ctrl
          type: device
          clock: clk_peri_i
          reset: rst_peri_ni
          pipeline: false
          inst_type: lc_ctrl
          addr_range:
          [
            {
              base_addr: 0x40140000
              size_byte: 0x100
            }
          ]
          xbar: false
          stub: false
          req_fifo_pass: true
        }
        {
          name: alert_handler
          type: device
          clock: clk_peri_i
          reset: rst_peri_ni
          pipeline: false
          inst_type: alert_handler
          addr_range:
          [
            {
              base_addr: 0x40150000
              size_byte: 0x800
            }
          ]
          xbar: false
          stub: false
          req_fifo_pass: true
        }
        {
          name: sram_ctrl_ret_aon.regs
          type: device
          clock: clk_peri_i
          reset: rst_peri_ni
          pipeline: false
          inst_type: sram_ctrl
          addr_range:
          [
            {
              base_addr: 0x40500000
              size_byte: 0x40
            }
          ]
          xbar: false
          stub: false
          req_fifo_pass: true
        }
        {
          name: sram_ctrl_ret_aon.ram
          type: device
          clock: clk_peri_i
          reset: rst_peri_ni
          pipeline: false
          inst_type: sram_ctrl
          addr_range:
          [
            {
              base_addr: 0x40600000
              size_byte: 0x1000
            }
          ]
          xbar: false
          stub: false
          req_fifo_pass: true
        }
        {
          name: aon_timer_aon
          type: device
          clock: clk_peri_i
          reset: rst_peri_ni
          pipeline: false
          inst_type: aon_timer
          addr_range:
          [
            {
              base_addr: 0x40470000
              size_byte: 0x40
            }
          ]
          xbar: false
          stub: false
          req_fifo_pass: true
        }
        {
          name: ast
          type: device
          clock: clk_peri_i
          reset: rst_peri_ni
          pipeline: false
          inst_type: ast
          addr_range:
          [
            {
              base_addr: 0x40480000
              size_byte: 0x400
            }
          ]
          xbar: false
          stub: true
          req_fifo_pass: true
        }
      ]
      clock: clk_peri_i
      type: xbar
      inter_signal_list:
      [
        {
          name: tl_main
          struct: tl
          package: tlul_pkg
          type: req_rsp
          act: rsp
          width: 1
          inst_name: peri
          default: ""
          top_signame: main_tl_peri
          index: -1
        }
        {
          name: tl_ergo_cdc_bridge0
          struct: tl
          package: tlul_pkg
          type: req_rsp
          act: req
          width: 1
          inst_name: peri
          default: ""
          top_signame: ergo_cdc_bridge0_tl
          index: -1
        }
        {
          name: tl_ergo_cdc_bridge1
          struct: tl
          package: tlul_pkg
          type: req_rsp
          act: req
          width: 1
          inst_name: peri
          default: ""
          top_signame: ergo_cdc_bridge1_tl
          index: -1
        }
        {
          name: tl_ergo_cdc_bridge2
          struct: tl
          package: tlul_pkg
          type: req_rsp
          act: req
          width: 1
          inst_name: peri
          default: ""
          top_signame: ergo_cdc_bridge2_tl
          index: -1
        }
        {
          name: tl_ergo_cdc_bridge3
          struct: tl
          package: tlul_pkg
          type: req_rsp
          act: req
          width: 1
          inst_name: peri
          default: ""
          top_signame: ergo_cdc_bridge3_tl
          index: -1
        }
        {
          name: tl_ergo_cdc_bridge4
          struct: tl
          package: tlul_pkg
          type: req_rsp
          act: req
          width: 1
          inst_name: peri
          default: ""
          top_signame: ergo_cdc_bridge4_tl
          index: -1
        }
        {
          name: tl_ergo_cdc_bridge5
          struct: tl
          package: tlul_pkg
          type: req_rsp
          act: req
          width: 1
          inst_name: peri
          default: ""
          top_signame: ergo_cdc_bridge5_tl
          index: -1
        }
        {
          name: tl_ergo_setup_gen0
          struct: tl
          package: tlul_pkg
          type: req_rsp
          act: req
          width: 1
          inst_name: peri
          default: ""
          top_signame: ergo_setup_gen0_tl
          index: -1
        }
        {
          name: tl_ergo_setup_gen1
          struct: tl
          package: tlul_pkg
          type: req_rsp
          act: req
          width: 1
          inst_name: peri
          default: ""
          top_signame: ergo_setup_gen1_tl
          index: -1
        }
        {
          name: tl_ergo_setup_gen2
          struct: tl
          package: tlul_pkg
          type: req_rsp
          act: req
          width: 1
          inst_name: peri
          default: ""
          top_signame: ergo_setup_gen2_tl
          index: -1
        }
        {
          name: tl_ergo_setup_gen3
          struct: tl
          package: tlul_pkg
          type: req_rsp
          act: req
          width: 1
          inst_name: peri
          default: ""
          top_signame: ergo_setup_gen3_tl
          index: -1
        }
        {
          name: tl_ergo_setup_gen4
          struct: tl
          package: tlul_pkg
          type: req_rsp
          act: req
          width: 1
          inst_name: peri
          default: ""
          top_signame: ergo_setup_gen4_tl
          index: -1
        }
        {
          name: tl_ergo_setup_gen5
          struct: tl
          package: tlul_pkg
          type: req_rsp
          act: req
          width: 1
          inst_name: peri
          default: ""
          top_signame: ergo_setup_gen5_tl
          index: -1
        }
        {
          name: tl_ergo_hold_gen0
          struct: tl
          package: tlul_pkg
          type: req_rsp
          act: req
          width: 1
          inst_name: peri
          default: ""
          top_signame: ergo_hold_gen0_tl
          index: -1
        }
        {
          name: tl_ergo_hold_gen1
          struct: tl
          package: tlul_pkg
          type: req_rsp
          act: req
          width: 1
          inst_name: peri
          default: ""
          top_signame: ergo_hold_gen1_tl
          index: -1
        }
        {
          name: tl_ergo_hold_gen2
          struct: tl
          package: tlul_pkg
          type: req_rsp
          act: req
          width: 1
          inst_name: peri
          default: ""
          top_signame: ergo_hold_gen2_tl
          index: -1
        }
        {
          name: tl_ergo_hold_gen3
          struct: tl
          package: tlul_pkg
          type: req_rsp
          act: req
          width: 1
          inst_name: peri
          default: ""
          top_signame: ergo_hold_gen3_tl
          index: -1
        }
        {
          name: tl_ergo_hold_gen4
          struct: tl
          package: tlul_pkg
          type: req_rsp
          act: req
          width: 1
          inst_name: peri
          default: ""
          top_signame: ergo_hold_gen4_tl
          index: -1
        }
        {
          name: tl_ergo_cdc_hazard_gen0
          struct: tl
          package: tlul_pkg
          type: req_rsp
          act: req
          width: 1
          inst_name: peri
          default: ""
          top_signame: ergo_cdc_hazard_gen0_tl
          index: -1
        }
        {
          name: tl_ergo_cdc_hazard_gen1
          struct: tl
          package: tlul_pkg
          type: req_rsp
          act: req
          width: 1
          inst_name: peri
          default: ""
          top_signame: ergo_cdc_hazard_gen1_tl
          index: -1
        }
        {
          name: tl_ergo_cdc_hazard_gen2
          struct: tl
          package: tlul_pkg
          type: req_rsp
          act: req
          width: 1
          inst_name: peri
          default: ""
          top_signame: ergo_cdc_hazard_gen2_tl
          index: -1
        }
        {
          name: tl_ergo_cdc_hazard_gen3
          struct: tl
          package: tlul_pkg
          type: req_rsp
          act: req
          width: 1
          inst_name: peri
          default: ""
          top_signame: ergo_cdc_hazard_gen3_tl
          index: -1
        }
        {
          name: tl_ergo_cdc_hazard_gen4
          struct: tl
          package: tlul_pkg
          type: req_rsp
          act: req
          width: 1
          inst_name: peri
          default: ""
          top_signame: ergo_cdc_hazard_gen4_tl
          index: -1
        }
        {
          name: tl_ergo_cdc_bridge6
          struct: tl
          package: tlul_pkg
          type: req_rsp
          act: req
          width: 1
          inst_name: peri
          default: ""
          top_signame: ergo_cdc_bridge6_tl
          index: -1
        }
        {
          name: tl_ergo_cdc_bridge7
          struct: tl
          package: tlul_pkg
          type: req_rsp
          act: req
          width: 1
          inst_name: peri
          default: ""
          top_signame: ergo_cdc_bridge7_tl
          index: -1
        }
        {
          name: tl_ergo_cdc_bridge8
          struct: tl
          package: tlul_pkg
          type: req_rsp
          act: req
          width: 1
          inst_name: peri
          default: ""
          top_signame: ergo_cdc_bridge8_tl
          index: -1
        }
        {
          name: tl_ergo_setup_gen6
          struct: tl
          package: tlul_pkg
          type: req_rsp
          act: req
          width: 1
          inst_name: peri
          default: ""
          top_signame: ergo_setup_gen6_tl
          index: -1
        }
        {
          name: tl_ergo_setup_gen7
          struct: tl
          package: tlul_pkg
          type: req_rsp
          act: req
          width: 1
          inst_name: peri
          default: ""
          top_signame: ergo_setup_gen7_tl
          index: -1
        }
        {
          name: tl_ergo_setup_gen8
          struct: tl
          package: tlul_pkg
          type: req_rsp
          act: req
          width: 1
          inst_name: peri
          default: ""
          top_signame: ergo_setup_gen8_tl
          index: -1
        }
        {
          name: tl_ergo_hold_gen5
          struct: tl
          package: tlul_pkg
          type: req_rsp
          act: req
          width: 1
          inst_name: peri
          default: ""
          top_signame: ergo_hold_gen5_tl
          index: -1
        }
        {
          name: tl_ergo_hold_gen6
          struct: tl
          package: tlul_pkg
          type: req_rsp
          act: req
          width: 1
          inst_name: peri
          default: ""
          top_signame: ergo_hold_gen6_tl
          index: -1
        }
        {
          name: tl_ergo_cdc_hazard_gen5
          struct: tl
          package: tlul_pkg
          type: req_rsp
          act: req
          width: 1
          inst_name: peri
          default: ""
          top_signame: ergo_cdc_hazard_gen5_tl
          index: -1
        }
        {
          name: tl_ergo_cdc_hazard_gen6
          struct: tl
          package: tlul_pkg
          type: req_rsp
          act: req
          width: 1
          inst_name: peri
          default: ""
          top_signame: ergo_cdc_hazard_gen6_tl
          index: -1
        }
        {
          name: tl_uart0
          struct: tl
          package: tlul_pkg
          type: req_rsp
          act: req
          width: 1
          inst_name: peri
          default: ""
          top_signame: uart0_tl
          index: -1
        }
        {
          name: tl_i2c0
          struct: tl
          package: tlul_pkg
          type: req_rsp
          act: req
          width: 1
          inst_name: peri
          default: ""
          top_signame: i2c0_tl
          index: -1
        }
        {
          name: tl_gpio
          struct: tl
          package: tlul_pkg
          type: req_rsp
          act: req
          width: 1
          inst_name: peri
          default: ""
          top_signame: gpio_tl
          index: -1
        }
        {
          name: tl_spi_device
          struct: tl
          package: tlul_pkg
          type: req_rsp
          act: req
          width: 1
          inst_name: peri
          default: ""
          top_signame: spi_device_tl
          index: -1
        }
        {
          name: tl_rv_timer
          struct: tl
          package: tlul_pkg
          type: req_rsp
          act: req
          width: 1
          inst_name: peri
          default: ""
          top_signame: rv_timer_tl
          index: -1
        }
        {
          name: tl_pwrmgr_aon
          struct: tl
          package: tlul_pkg
          type: req_rsp
          act: req
          width: 1
          inst_name: peri
          default: ""
          top_signame: pwrmgr_aon_tl
          index: -1
        }
        {
          name: tl_rstmgr_aon
          struct: tl
          package: tlul_pkg
          type: req_rsp
          act: req
          width: 1
          inst_name: peri
          default: ""
          top_signame: rstmgr_aon_tl
          index: -1
        }
        {
          name: tl_clkmgr_aon
          struct: tl
          package: tlul_pkg
          type: req_rsp
          act: req
          width: 1
          inst_name: peri
          default: ""
          top_signame: clkmgr_aon_tl
          index: -1
        }
        {
          name: tl_pinmux_aon
          struct: tl
          package: tlul_pkg
          type: req_rsp
          act: req
          width: 1
          inst_name: peri
          default: ""
          top_signame: pinmux_aon_tl
          index: -1
        }
        {
          name: tl_otp_ctrl__core
          struct: tl
          package: tlul_pkg
          type: req_rsp
          act: req
          width: 1
          inst_name: peri
          default: ""
          top_signame: otp_ctrl_core_tl
          index: -1
        }
        {
          name: tl_otp_ctrl__prim
          struct: tl
          package: tlul_pkg
          type: req_rsp
          act: req
          width: 1
          inst_name: peri
          default: ""
          top_signame: otp_ctrl_prim_tl
          index: -1
        }
        {
          name: tl_lc_ctrl
          struct: tl
          package: tlul_pkg
          type: req_rsp
          act: req
          width: 1
          inst_name: peri
          default: ""
          top_signame: lc_ctrl_tl
          index: -1
        }
        {
          name: tl_alert_handler
          struct: tl
          package: tlul_pkg
          type: req_rsp
          act: req
          width: 1
          inst_name: peri
          default: ""
          top_signame: alert_handler_tl
          index: -1
        }
        {
          name: tl_sram_ctrl_ret_aon__regs
          struct: tl
          package: tlul_pkg
          type: req_rsp
          act: req
          width: 1
          inst_name: peri
          default: ""
          top_signame: sram_ctrl_ret_aon_regs_tl
          index: -1
        }
        {
          name: tl_sram_ctrl_ret_aon__ram
          struct: tl
          package: tlul_pkg
          type: req_rsp
          act: req
          width: 1
          inst_name: peri
          default: ""
          top_signame: sram_ctrl_ret_aon_ram_tl
          index: -1
        }
        {
          name: tl_aon_timer_aon
          struct: tl
          package: tlul_pkg
          type: req_rsp
          act: req
          width: 1
          inst_name: peri
          default: ""
          top_signame: aon_timer_aon_tl
          index: -1
        }
        {
          name: tl_ast
          struct: tl
          package: tlul_pkg
          type: req_rsp
          act: req
          width: 1
          inst_name: peri
          default: ""
          external: true
          top_signame: ast_tl
          conn_type: false
          index: -1
        }
      ]
    }
  ]
  pinout:
  {
    banks:
    [
      VCC
      AVCC
      VIOA
      VIOB
    ]
    pads:
    [
      {
        name: POR_N
        type: InputStd
        bank: VCC
        connection: manual
        desc: System reset
        port_type: inout
        idx: 0
      }
      {
        name: USB_P
        type: DualBidirTol
        bank: VCC
        connection: manual
        desc: USB P signal
        port_type: inout
        idx: 1
      }
      {
        name: USB_N
        type: DualBidirTol
        bank: VCC
        connection: manual
        desc: USB N signal
        port_type: inout
        idx: 2
      }
      {
        name: CC1
        type: BidirTol
        bank: AVCC
        connection: manual
        desc: ADC input 1
        port_type: `INOUT_AI
        idx: 3
      }
      {
        name: CC2
        type: BidirTol
        bank: AVCC
        connection: manual
        desc: ADC input 2
        port_type: `INOUT_AI
        idx: 4
      }
      {
        name: FLASH_TEST_VOLT
        type: AnalogIn0
        bank: VCC
        connection: manual
        desc: Flash test voltage input
        port_type: inout
        idx: 5
      }
      {
        name: FLASH_TEST_MODE0
        type: InputStd
        bank: VCC
        connection: manual
        desc: Flash test mode signal
        port_type: inout
        idx: 6
      }
      {
        name: FLASH_TEST_MODE1
        type: InputStd
        bank: VCC
        connection: manual
        desc: Flash test mode signal
        port_type: inout
        idx: 7
      }
      {
        name: OTP_EXT_VOLT
        type: AnalogIn1
        bank: VCC
        connection: manual
        desc: OTP external voltage input
        port_type: inout
        idx: 8
      }
      {
        name: SPI_HOST_D0
        type: BidirStd
        bank: VIOA
        connection: direct
        desc: SPI host data
        port_type: inout
        idx: 9
      }
      {
        name: SPI_HOST_D1
        type: BidirStd
        bank: VIOA
        connection: direct
        desc: SPI host data
        port_type: inout
        idx: 10
      }
      {
        name: SPI_HOST_D2
        type: BidirStd
        bank: VIOA
        connection: direct
        desc: SPI host data
        port_type: inout
        idx: 11
      }
      {
        name: SPI_HOST_D3
        type: BidirStd
        bank: VIOA
        connection: direct
        desc: SPI host data
        port_type: inout
        idx: 12
      }
      {
        name: SPI_HOST_CLK
        type: BidirStd
        bank: VIOA
        connection: direct
        desc: SPI host clock
        port_type: inout
        idx: 13
      }
      {
        name: SPI_HOST_CS_L
        type: BidirStd
        bank: VIOA
        connection: direct
        desc: SPI host chip select
        port_type: inout
        idx: 14
      }
      {
        name: SPI_DEV_D0
        type: BidirStd
        bank: VIOA
        connection: direct
        desc: SPI device data
        port_type: inout
        idx: 15
      }
      {
        name: SPI_DEV_D1
        type: BidirStd
        bank: VIOA
        connection: direct
        desc: SPI device data
        port_type: inout
        idx: 16
      }
      {
        name: SPI_DEV_D2
        type: BidirStd
        bank: VIOA
        connection: direct
        desc: SPI device data
        port_type: inout
        idx: 17
      }
      {
        name: SPI_DEV_D3
        type: BidirStd
        bank: VIOA
        connection: direct
        desc: SPI device data
        port_type: inout
        idx: 18
      }
      {
        name: SPI_DEV_CLK
        type: InputStd
        bank: VIOA
        connection: direct
        desc: SPI device clock
        port_type: inout
        idx: 19
      }
      {
        name: SPI_DEV_CS_L
        type: InputStd
        bank: VIOA
        connection: direct
        desc: SPI device chip select
        port_type: inout
        idx: 20
      }
      {
        name: IOA0
        type: BidirStd
        bank: VIOA
        connection: muxed
        desc: Muxed IO pad
        port_type: inout
        idx: 0
      }
      {
        name: IOA1
        type: BidirStd
        bank: VIOA
        connection: muxed
        desc: Muxed IO pad
        port_type: inout
        idx: 1
      }
      {
        name: IOA2
        type: BidirStd
        bank: VIOA
        connection: muxed
        desc: Muxed IO pad
        port_type: `INOUT_AO
        idx: 2
      }
      {
        name: IOA3
        type: BidirStd
        bank: VIOA
        connection: muxed
        desc: Muxed IO pad
        port_type: `INOUT_AO
        idx: 3
      }
      {
        name: IOA4
        type: BidirStd
        bank: VIOA
        connection: muxed
        desc: Muxed IO pad
        port_type: inout
        idx: 4
      }
      {
        name: IOA5
        type: BidirStd
        bank: VIOA
        connection: muxed
        desc: Muxed IO pad
        port_type: inout
        idx: 5
      }
      {
        name: IOA6
        type: BidirOd
        bank: VIOA
        connection: muxed
        desc: Muxed IO pad
        port_type: inout
        idx: 6
      }
      {
        name: IOA7
        type: BidirOd
        bank: VIOA
        connection: muxed
        desc: Muxed IO pad
        port_type: inout
        idx: 7
      }
      {
        name: IOA8
        type: BidirOd
        bank: VIOA
        connection: muxed
        desc: Muxed IO pad
        port_type: inout
        idx: 8
      }
      {
        name: IOB0
        type: BidirStd
        bank: VIOB
        connection: muxed
        desc: Muxed IO pad
        port_type: inout
        idx: 9
      }
      {
        name: IOB1
        type: BidirStd
        bank: VIOB
        connection: muxed
        desc: Muxed IO pad
        port_type: inout
        idx: 10
      }
      {
        name: IOB2
        type: BidirStd
        bank: VIOB
        connection: muxed
        desc: Muxed IO pad
        port_type: inout
        idx: 11
      }
      {
        name: IOB3
        type: BidirStd
        bank: VIOB
        connection: muxed
        desc: Muxed IO pad
        port_type: inout
        idx: 12
      }
      {
        name: IOB4
        type: BidirStd
        bank: VIOB
        connection: muxed
        desc: Muxed IO pad
        port_type: inout
        idx: 13
      }
      {
        name: IOB5
        type: BidirStd
        bank: VIOB
        connection: muxed
        desc: Muxed IO pad
        port_type: inout
        idx: 14
      }
      {
        name: IOB6
        type: BidirStd
        bank: VIOB
        connection: muxed
        desc: Muxed IO pad
        port_type: inout
        idx: 15
      }
      {
        name: IOB7
        type: BidirStd
        bank: VIOB
        connection: muxed
        desc: Muxed IO pad
        port_type: inout
        idx: 16
      }
      {
        name: IOB8
        type: BidirStd
        bank: VIOB
        connection: muxed
        desc: Muxed IO pad
        port_type: inout
        idx: 17
      }
      {
        name: IOB9
        type: BidirOd
        bank: VIOB
        connection: muxed
        desc: Muxed IO pad
        port_type: inout
        idx: 18
      }
      {
        name: IOB10
        type: BidirOd
        bank: VIOB
        connection: muxed
        desc: Muxed IO pad
        port_type: inout
        idx: 19
      }
      {
        name: IOB11
        type: BidirOd
        bank: VIOB
        connection: muxed
        desc: Muxed IO pad
        port_type: inout
        idx: 20
      }
      {
        name: IOB12
        type: BidirOd
        bank: VIOB
        connection: muxed
        desc: Muxed IO pad
        port_type: inout
        idx: 21
      }
      {
        name: IOC0
        type: BidirStd
        bank: VCC
        connection: muxed
        desc: Muxed IO pad
        port_type: inout
        idx: 22
      }
      {
        name: IOC1
        type: BidirStd
        bank: VCC
        connection: muxed
        desc: Muxed IO pad
        port_type: inout
        idx: 23
      }
      {
        name: IOC2
        type: BidirStd
        bank: VCC
        connection: muxed
        desc: Muxed IO pad
        port_type: inout
        idx: 24
      }
      {
        name: IOC3
        type: BidirStd
        bank: VCC
        connection: muxed
        desc: Muxed IO pad
        port_type: inout
        idx: 25
      }
      {
        name: IOC4
        type: BidirStd
        bank: VCC
        connection: muxed
        desc: Muxed IO pad
        port_type: inout
        idx: 26
      }
      {
        name: IOC5
        type: BidirStd
        bank: VCC
        connection: muxed
        desc: Muxed IO pad
        port_type: inout
        idx: 27
      }
      {
        name: IOC6
        type: BidirStd
        bank: VCC
        connection: muxed
        desc: Muxed IO pad
        port_type: inout
        idx: 28
      }
      {
        name: IOC7
        type: BidirStd
        bank: VCC
        connection: muxed
        desc: Muxed IO pad
        port_type: inout
        idx: 29
      }
      {
        name: IOC8
        type: BidirStd
        bank: VCC
        connection: muxed
        desc: Muxed IO pad
        port_type: inout
        idx: 30
      }
      {
        name: IOC9
        type: BidirStd
        bank: VCC
        connection: muxed
        desc: Muxed IO pad
        port_type: inout
        idx: 31
      }
      {
        name: IOC10
        type: BidirOd
        bank: VCC
        connection: muxed
        desc: Muxed IO pad
        port_type: inout
        idx: 32
      }
      {
        name: IOC11
        type: BidirOd
        bank: VCC
        connection: muxed
        desc: Muxed IO pad
        port_type: inout
        idx: 33
      }
      {
        name: IOC12
        type: BidirOd
        bank: VCC
        connection: muxed
        desc: Muxed IO pad
        port_type: inout
        idx: 34
      }
      {
        name: IOR0
        type: BidirStd
        bank: VCC
        connection: muxed
        desc: Muxed IO pad
        port_type: inout
        idx: 35
      }
      {
        name: IOR1
        type: BidirStd
        bank: VCC
        connection: muxed
        desc: Muxed IO pad
        port_type: inout
        idx: 36
      }
      {
        name: IOR2
        type: BidirStd
        bank: VCC
        connection: muxed
        desc: Muxed IO pad
        port_type: inout
        idx: 37
      }
      {
        name: IOR3
        type: BidirStd
        bank: VCC
        connection: muxed
        desc: Muxed IO pad
        port_type: inout
        idx: 38
      }
      {
        name: IOR4
        type: BidirStd
        bank: VCC
        connection: muxed
        desc: Muxed IO pad
        port_type: inout
        idx: 39
      }
      {
        name: IOR5
        type: BidirStd
        bank: VCC
        connection: muxed
        desc: Muxed IO pad
        port_type: inout
        idx: 40
      }
      {
        name: IOR6
        type: BidirStd
        bank: VCC
        connection: muxed
        desc: Muxed IO pad
        port_type: inout
        idx: 41
      }
      {
        name: IOR7
        type: BidirStd
        bank: VCC
        connection: muxed
        desc: Muxed IO pad
        port_type: inout
        idx: 42
      }
      {
        name: IOR10
        type: BidirOd
        bank: VCC
        connection: muxed
        desc: Muxed IO pad
        port_type: inout
        idx: 43
      }
      {
        name: IOR11
        type: BidirOd
        bank: VCC
        connection: muxed
        desc: Muxed IO pad
        port_type: inout
        idx: 44
      }
      {
        name: IOR12
        type: BidirOd
        bank: VCC
        connection: muxed
        desc: Muxed IO pad
        port_type: inout
        idx: 45
      }
      {
        name: IOR13
        type: BidirOd
        bank: VCC
        connection: muxed
        desc: Muxed IO pad
        port_type: inout
        idx: 46
      }
    ]
  }
  pinmux:
  {
    signals:
    [
      {
        instance: spi_host0
        port: sck
        connection: direct
        pad: SPI_HOST_CLK
        desc: ""
        attr: BidirStd
      }
      {
        instance: spi_host0
        port: csb
        connection: direct
        pad: SPI_HOST_CS_L
        desc: ""
        attr: BidirStd
      }
      {
        instance: spi_host0
        port: sd[0]
        connection: direct
        pad: SPI_HOST_D0
        desc: ""
        attr: BidirStd
      }
      {
        instance: spi_host0
        port: sd[1]
        connection: direct
        pad: SPI_HOST_D1
        desc: ""
        attr: BidirStd
      }
      {
        instance: spi_host0
        port: sd[2]
        connection: direct
        pad: SPI_HOST_D2
        desc: ""
        attr: BidirStd
      }
      {
        instance: spi_host0
        port: sd[3]
        connection: direct
        pad: SPI_HOST_D3
        desc: ""
        attr: BidirStd
      }
      {
        instance: spi_device
        port: sck
        connection: direct
        pad: SPI_DEV_CLK
        desc: ""
        attr: InputStd
      }
      {
        instance: spi_device
        port: csb
        connection: direct
        pad: SPI_DEV_CS_L
        desc: ""
        attr: InputStd
      }
      {
        instance: spi_device
        port: sd[0]
        connection: direct
        pad: SPI_DEV_D0
        desc: ""
        attr: BidirStd
      }
      {
        instance: spi_device
        port: sd[1]
        connection: direct
        pad: SPI_DEV_D1
        desc: ""
        attr: BidirStd
      }
      {
        instance: spi_device
        port: sd[2]
        connection: direct
        pad: SPI_DEV_D2
        desc: ""
        attr: BidirStd
      }
      {
        instance: spi_device
        port: sd[3]
        connection: direct
        pad: SPI_DEV_D3
        desc: ""
        attr: BidirStd
      }
      {
        instance: gpio
        port: ""
        connection: muxed
        pad: ""
        desc: ""
        attr: ""
      }
      {
        instance: uart0
        port: ""
        connection: muxed
        pad: ""
        desc: ""
        attr: ""
      }
      {
        instance: i2c0
        port: ""
        connection: muxed
        pad: ""
        desc: ""
        attr: ""
      }
      {
        instance: spi_device
        port: tpm_csb
        connection: muxed
        pad: ""
        desc: ""
        attr: ""
      }
      {
        instance: flash_ctrl
        port: ""
        connection: muxed
        pad: ""
        desc: ""
        attr: ""
      }
      {
        instance: otp_ctrl
        port: test[0]
        connection: muxed
        pad: ""
        desc: ""
        attr: ""
      }
    ]
    num_wkup_detect: 8
    wkup_cnt_width: 8
    ios:
    [
      {
        name: spi_host0_sd
        width: 4
        type: inout
        idx: 0
        pad: SPI_HOST_D0
        attr: BidirStd
        connection: direct
        desc: ""
        glob_idx: 0
      }
      {
        name: spi_host0_sd
        width: 4
        type: inout
        idx: 1
        pad: SPI_HOST_D1
        attr: BidirStd
        connection: direct
        desc: ""
        glob_idx: 1
      }
      {
        name: spi_host0_sd
        width: 4
        type: inout
        idx: 2
        pad: SPI_HOST_D2
        attr: BidirStd
        connection: direct
        desc: ""
        glob_idx: 2
      }
      {
        name: spi_host0_sd
        width: 4
        type: inout
        idx: 3
        pad: SPI_HOST_D3
        attr: BidirStd
        connection: direct
        desc: ""
        glob_idx: 3
      }
      {
        name: spi_device_sd
        width: 4
        type: inout
        idx: 0
        pad: SPI_DEV_D0
        attr: BidirStd
        connection: direct
        desc: ""
        glob_idx: 4
      }
      {
        name: spi_device_sd
        width: 4
        type: inout
        idx: 1
        pad: SPI_DEV_D1
        attr: BidirStd
        connection: direct
        desc: ""
        glob_idx: 5
      }
      {
        name: spi_device_sd
        width: 4
        type: inout
        idx: 2
        pad: SPI_DEV_D2
        attr: BidirStd
        connection: direct
        desc: ""
        glob_idx: 6
      }
      {
        name: spi_device_sd
        width: 4
        type: inout
        idx: 3
        pad: SPI_DEV_D3
        attr: BidirStd
        connection: direct
        desc: ""
        glob_idx: 7
      }
      {
        name: gpio_gpio
        width: 32
        type: inout
        idx: 0
        pad: ""
        attr: ""
        connection: muxed
        desc: ""
        glob_idx: 0
      }
      {
        name: gpio_gpio
        width: 32
        type: inout
        idx: 1
        pad: ""
        attr: ""
        connection: muxed
        desc: ""
        glob_idx: 1
      }
      {
        name: gpio_gpio
        width: 32
        type: inout
        idx: 2
        pad: ""
        attr: ""
        connection: muxed
        desc: ""
        glob_idx: 2
      }
      {
        name: gpio_gpio
        width: 32
        type: inout
        idx: 3
        pad: ""
        attr: ""
        connection: muxed
        desc: ""
        glob_idx: 3
      }
      {
        name: gpio_gpio
        width: 32
        type: inout
        idx: 4
        pad: ""
        attr: ""
        connection: muxed
        desc: ""
        glob_idx: 4
      }
      {
        name: gpio_gpio
        width: 32
        type: inout
        idx: 5
        pad: ""
        attr: ""
        connection: muxed
        desc: ""
        glob_idx: 5
      }
      {
        name: gpio_gpio
        width: 32
        type: inout
        idx: 6
        pad: ""
        attr: ""
        connection: muxed
        desc: ""
        glob_idx: 6
      }
      {
        name: gpio_gpio
        width: 32
        type: inout
        idx: 7
        pad: ""
        attr: ""
        connection: muxed
        desc: ""
        glob_idx: 7
      }
      {
        name: gpio_gpio
        width: 32
        type: inout
        idx: 8
        pad: ""
        attr: ""
        connection: muxed
        desc: ""
        glob_idx: 8
      }
      {
        name: gpio_gpio
        width: 32
        type: inout
        idx: 9
        pad: ""
        attr: ""
        connection: muxed
        desc: ""
        glob_idx: 9
      }
      {
        name: gpio_gpio
        width: 32
        type: inout
        idx: 10
        pad: ""
        attr: ""
        connection: muxed
        desc: ""
        glob_idx: 10
      }
      {
        name: gpio_gpio
        width: 32
        type: inout
        idx: 11
        pad: ""
        attr: ""
        connection: muxed
        desc: ""
        glob_idx: 11
      }
      {
        name: gpio_gpio
        width: 32
        type: inout
        idx: 12
        pad: ""
        attr: ""
        connection: muxed
        desc: ""
        glob_idx: 12
      }
      {
        name: gpio_gpio
        width: 32
        type: inout
        idx: 13
        pad: ""
        attr: ""
        connection: muxed
        desc: ""
        glob_idx: 13
      }
      {
        name: gpio_gpio
        width: 32
        type: inout
        idx: 14
        pad: ""
        attr: ""
        connection: muxed
        desc: ""
        glob_idx: 14
      }
      {
        name: gpio_gpio
        width: 32
        type: inout
        idx: 15
        pad: ""
        attr: ""
        connection: muxed
        desc: ""
        glob_idx: 15
      }
      {
        name: gpio_gpio
        width: 32
        type: inout
        idx: 16
        pad: ""
        attr: ""
        connection: muxed
        desc: ""
        glob_idx: 16
      }
      {
        name: gpio_gpio
        width: 32
        type: inout
        idx: 17
        pad: ""
        attr: ""
        connection: muxed
        desc: ""
        glob_idx: 17
      }
      {
        name: gpio_gpio
        width: 32
        type: inout
        idx: 18
        pad: ""
        attr: ""
        connection: muxed
        desc: ""
        glob_idx: 18
      }
      {
        name: gpio_gpio
        width: 32
        type: inout
        idx: 19
        pad: ""
        attr: ""
        connection: muxed
        desc: ""
        glob_idx: 19
      }
      {
        name: gpio_gpio
        width: 32
        type: inout
        idx: 20
        pad: ""
        attr: ""
        connection: muxed
        desc: ""
        glob_idx: 20
      }
      {
        name: gpio_gpio
        width: 32
        type: inout
        idx: 21
        pad: ""
        attr: ""
        connection: muxed
        desc: ""
        glob_idx: 21
      }
      {
        name: gpio_gpio
        width: 32
        type: inout
        idx: 22
        pad: ""
        attr: ""
        connection: muxed
        desc: ""
        glob_idx: 22
      }
      {
        name: gpio_gpio
        width: 32
        type: inout
        idx: 23
        pad: ""
        attr: ""
        connection: muxed
        desc: ""
        glob_idx: 23
      }
      {
        name: gpio_gpio
        width: 32
        type: inout
        idx: 24
        pad: ""
        attr: ""
        connection: muxed
        desc: ""
        glob_idx: 24
      }
      {
        name: gpio_gpio
        width: 32
        type: inout
        idx: 25
        pad: ""
        attr: ""
        connection: muxed
        desc: ""
        glob_idx: 25
      }
      {
        name: gpio_gpio
        width: 32
        type: inout
        idx: 26
        pad: ""
        attr: ""
        connection: muxed
        desc: ""
        glob_idx: 26
      }
      {
        name: gpio_gpio
        width: 32
        type: inout
        idx: 27
        pad: ""
        attr: ""
        connection: muxed
        desc: ""
        glob_idx: 27
      }
      {
        name: gpio_gpio
        width: 32
        type: inout
        idx: 28
        pad: ""
        attr: ""
        connection: muxed
        desc: ""
        glob_idx: 28
      }
      {
        name: gpio_gpio
        width: 32
        type: inout
        idx: 29
        pad: ""
        attr: ""
        connection: muxed
        desc: ""
        glob_idx: 29
      }
      {
        name: gpio_gpio
        width: 32
        type: inout
        idx: 30
        pad: ""
        attr: ""
        connection: muxed
        desc: ""
        glob_idx: 30
      }
      {
        name: gpio_gpio
        width: 32
        type: inout
        idx: 31
        pad: ""
        attr: ""
        connection: muxed
        desc: ""
        glob_idx: 31
      }
      {
        name: i2c0_sda
        width: 1
        type: inout
        idx: -1
        pad: ""
        attr: ""
        connection: muxed
        desc: ""
        glob_idx: 32
      }
      {
        name: i2c0_scl
        width: 1
        type: inout
        idx: -1
        pad: ""
        attr: ""
        connection: muxed
        desc: ""
        glob_idx: 33
      }
      {
        name: spi_device_sck
        width: 1
        type: input
        idx: -1
        pad: SPI_DEV_CLK
        attr: InputStd
        connection: direct
        desc: ""
        glob_idx: 8
      }
      {
        name: spi_device_csb
        width: 1
        type: input
        idx: -1
        pad: SPI_DEV_CS_L
        attr: InputStd
        connection: direct
        desc: ""
        glob_idx: 9
      }
      {
        name: uart0_rx
        width: 1
        type: input
        idx: -1
        pad: ""
        attr: ""
        connection: muxed
        desc: ""
        glob_idx: 34
      }
      {
        name: spi_device_tpm_csb
        width: 1
        type: input
        idx: -1
        pad: ""
        attr: ""
        connection: muxed
        desc: ""
        glob_idx: 35
      }
      {
        name: flash_ctrl_tck
        width: 1
        type: input
        idx: -1
        pad: ""
        attr: ""
        connection: muxed
        desc: ""
        glob_idx: 36
      }
      {
        name: flash_ctrl_tms
        width: 1
        type: input
        idx: -1
        pad: ""
        attr: ""
        connection: muxed
        desc: ""
        glob_idx: 37
      }
      {
        name: flash_ctrl_tdi
        width: 1
        type: input
        idx: -1
        pad: ""
        attr: ""
        connection: muxed
        desc: ""
        glob_idx: 38
      }
      {
        name: spi_host0_sck
        width: 1
        type: output
        idx: -1
        pad: SPI_HOST_CLK
        attr: BidirStd
        connection: direct
        desc: ""
        glob_idx: 10
      }
      {
        name: spi_host0_csb
        width: 1
        type: output
        idx: -1
        pad: SPI_HOST_CS_L
        attr: BidirStd
        connection: direct
        desc: ""
        glob_idx: 11
      }
      {
        name: uart0_tx
        width: 1
        type: output
        idx: -1
        pad: ""
        attr: ""
        connection: muxed
        desc: ""
        glob_idx: 34
      }
      {
        name: flash_ctrl_tdo
        width: 1
        type: output
        idx: -1
        pad: ""
        attr: ""
        connection: muxed
        desc: ""
        glob_idx: 35
      }
      {
        name: otp_ctrl_test
        width: 8
        type: output
        idx: 0
        pad: ""
        attr: ""
        connection: muxed
        desc: ""
        glob_idx: 36
      }
    ]
    io_counts:
    {
      dedicated:
      {
        inouts: 8
        inputs: 2
        outputs: 2
        pads: 21
      }
      muxed:
      {
        inouts: 34
        inputs: 5
        outputs: 3
        pads: 47
      }
    }
  }
  targets:
  [
    {
      name: asic
      pinout:
      {
        remove_ports: []
        remove_pads: []
        add_pads: []
      }
      pinmux:
      {
        special_signals:
        [
          {
            name: tap0
            pad: IOC8
            desc: TAP strap signal.
            idx: 30
          }
          {
            name: tap1
            pad: IOC5
            desc: TAP strap signal.
            idx: 27
          }
          {
            name: dft0
            pad: IOR5
            desc: DFT strap signal.
            idx: 40
          }
          {
            name: dft1
            pad: IOR7
            desc: DFT strap signal.
            idx: 42
          }
          {
            name: tck
            pad: IOR3
            desc: JTAG tck signal.
            idx: 38
          }
          {
            name: tms
            pad: IOR0
            desc: JTAG tms signal.
            idx: 35
          }
          {
            name: trst_n
            pad: IOR4
            desc: JTAG trst_n signal.
            idx: 39
          }
          {
            name: tdi
            pad: IOR2
            desc: JTAG tdi signal.
            idx: 37
          }
          {
            name: tdo
            pad: IOR1
            desc: JTAG tdo signal.
            idx: 36
          }
        ]
      }
    }
    {
      name: cw310
      pinout:
      {
        remove_ports: []
        remove_pads:
        [
          CC1
          CC2
          FLASH_TEST_VOLT
          OTP_EXT_VOLT
          FLASH_TEST_MODE0
          FLASH_TEST_MODE1
          USB_P
          USB_N
        ]
        add_pads:
        [
          {
            name: IO_CLK
            type: InputStd
            bank: VCC
            connection: manual
            desc: Extra clock input for FPGA target
            port_type: inout
          }
          {
            name: POR_BUTTON_N
            type: InputStd
            bank: VCC
            connection: manual
            desc: Power-on reset button input
            port_type: inout
          }
          {
            name: IO_USB_CONNECT
            type: BidirStd
            bank: VCC
            connection: manual
            desc: Manual USB UPHY signal for FPGA target
            port_type: inout
          }
          {
            name: IO_USB_DP_TX
            type: BidirStd
            bank: VCC
            connection: manual
            desc: Manual USB UPHY signal for FPGA target
            port_type: inout
          }
          {
            name: IO_USB_DN_TX
            type: BidirStd
            bank: VCC
            connection: manual
            desc: Manual USB UPHY signal for FPGA target
            port_type: inout
          }
          {
            name: IO_USB_D_RX
            type: BidirStd
            bank: VCC
            connection: manual
            desc: Manual USB UPHY signal for FPGA target
            port_type: inout
          }
          {
            name: IO_USB_DP_RX
            type: BidirStd
            bank: VCC
            connection: manual
            desc: Manual USB UPHY signal for FPGA target
            port_type: inout
          }
          {
            name: IO_USB_DN_RX
            type: BidirStd
            bank: VCC
            connection: manual
            desc: Manual USB UPHY signal for FPGA target
            port_type: inout
          }
          {
            name: IO_USB_OE_N
            type: BidirStd
            bank: VCC
            connection: manual
            desc: Manual USB UPHY signal for FPGA target
            port_type: inout
          }
          {
            name: IO_USB_SPEED
            type: BidirStd
            bank: VCC
            connection: manual
            desc: Manual USB UPHY signal for FPGA target
            port_type: inout
          }
          {
            name: IO_USB_SUSPEND
            type: BidirStd
            bank: VCC
            connection: manual
            desc: Manual USB UPHY signal for FPGA target
            port_type: inout
          }
          {
            name: IO_CLKOUT
            type: BidirStd
            bank: VCC
            connection: manual
            desc: Manual clock output for SCA setup
            port_type: inout
          }
          {
            name: IO_TRIGGER
            type: BidirStd
            bank: VCC
            connection: manual
            desc: Manual trigger output for SCA setup
            port_type: inout
          }
        ]
      }
      pinmux:
      {
        special_signals:
        [
          {
            name: tap0
            pad: IOC8
            desc: TAP strap signal.
            idx: 30
          }
          {
            name: tap1
            pad: IOC5
            desc: TAP strap signal.
            idx: 27
          }
          {
            name: dft0
            pad: IOR5
            desc: DFT strap signal.
            idx: 40
          }
          {
            name: dft1
            pad: IOR7
            desc: DFT strap signal.
            idx: 42
          }
          {
            name: tck
            pad: IOR3
            desc: JTAG tck signal.
            idx: 38
          }
          {
            name: tms
            pad: IOR0
            desc: JTAG tms signal.
            idx: 35
          }
          {
            name: trst_n
            pad: IOR4
            desc: JTAG trst_n signal.
            idx: 39
          }
          {
            name: tdi
            pad: IOR2
            desc: JTAG tdi signal.
            idx: 37
          }
          {
            name: tdo
            pad: IOR1
            desc: JTAG tdo signal.
            idx: 36
          }
        ]
      }
    }
    {
      name: cw340
      pinout:
      {
        remove_ports: []
        remove_pads:
        [
          CC1
          CC2
          FLASH_TEST_VOLT
          OTP_EXT_VOLT
          FLASH_TEST_MODE0
          FLASH_TEST_MODE1
          USB_P
          USB_N
        ]
        add_pads:
        [
          {
            name: IO_CLK
            type: InputStd
            bank: VCC
            connection: manual
            desc: Extra clock input for FPGA target
            port_type: inout
          }
          {
            name: IO_USB_CONNECT
            type: BidirStd
            bank: VCC
            connection: manual
            desc: Manual USB UPHY signal for FPGA target
            port_type: inout
          }
          {
            name: IO_USB_DP_TX
            type: BidirStd
            bank: VCC
            connection: manual
            desc: Manual USB UPHY signal for FPGA target
            port_type: inout
          }
          {
            name: IO_USB_DN_TX
            type: BidirStd
            bank: VCC
            connection: manual
            desc: Manual USB UPHY signal for FPGA target
            port_type: inout
          }
          {
            name: IO_USB_D_RX
            type: BidirStd
            bank: VCC
            connection: manual
            desc: Manual USB UPHY signal for FPGA target
            port_type: inout
          }
          {
            name: IO_USB_DP_RX
            type: BidirStd
            bank: VCC
            connection: manual
            desc: Manual USB UPHY signal for FPGA target
            port_type: inout
          }
          {
            name: IO_USB_DN_RX
            type: BidirStd
            bank: VCC
            connection: manual
            desc: Manual USB UPHY signal for FPGA target
            port_type: inout
          }
          {
            name: IO_USB_OE_N
            type: BidirStd
            bank: VCC
            connection: manual
            desc: Manual USB UPHY signal for FPGA target
            port_type: inout
          }
          {
            name: IO_USB_SPEED
            type: BidirStd
            bank: VCC
            connection: manual
            desc: Manual USB UPHY signal for FPGA target
            port_type: inout
          }
          {
            name: IO_USB_SUSPEND
            type: BidirStd
            bank: VCC
            connection: manual
            desc: Manual USB UPHY signal for FPGA target
            port_type: inout
          }
          {
            name: IO_CLKOUT
            type: BidirStd
            bank: VCC
            connection: manual
            desc: Manual clock output for SCA setup
            port_type: inout
          }
          {
            name: IO_TRIGGER
            type: BidirStd
            bank: VCC
            connection: manual
            desc: Manual trigger output for SCA setup
            port_type: inout
          }
        ]
      }
      pinmux:
      {
        special_signals:
        [
          {
            name: tap0
            pad: IOC8
            desc: TAP strap signal.
            idx: 30
          }
          {
            name: tap1
            pad: IOC5
            desc: TAP strap signal.
            idx: 27
          }
          {
            name: dft0
            pad: IOR5
            desc: DFT strap signal.
            idx: 40
          }
          {
            name: dft1
            pad: IOR7
            desc: DFT strap signal.
            idx: 42
          }
          {
            name: tck
            pad: IOR3
            desc: JTAG tck signal.
            idx: 38
          }
          {
            name: tms
            pad: IOR0
            desc: JTAG tms signal.
            idx: 35
          }
          {
            name: trst_n
            pad: IOR4
            desc: JTAG trst_n signal.
            idx: 39
          }
          {
            name: tdi
            pad: IOR2
            desc: JTAG tdi signal.
            idx: 37
          }
          {
            name: tdo
            pad: IOR1
            desc: JTAG tdo signal.
            idx: 36
          }
        ]
      }
    }
  ]
  exported_clks: {}
  wakeups:
  [
    {
      name: pin_wkup_req
      width: "1"
      module: pinmux_aon
    }
    {
      name: usb_wkup_req
      width: "1"
      module: pinmux_aon
    }
    {
      name: wkup_req
      width: "1"
      module: aon_timer_aon
    }
  ]
  reset_requests:
  {
    peripheral:
    [
      {
        name: aon_timer_rst_req
        width: "1"
        module: aon_timer_aon
        desc: watchdog reset requestt
      }
    ]
    int:
    [
      {
        name: MainPwr
        desc: main power glitch reset request
        module: pwrmgr_aon
      }
      {
        name: Esc
        desc: escalation reset request
        module: alert_handler
      }
    ]
    debug:
    [
      {
        name: Ndm
        desc: non-debug-module reset request
        module: rv_dm
      }
    ]
  }
  interrupt_module:
  [
    uart0
    gpio
    spi_device
    i2c0
    rv_timer
    kmac
    otp_ctrl
    alert_handler
    spi_host0
    pwrmgr_aon
    aon_timer_aon
    flash_ctrl
    keymgr
    csrng
    entropy_src
    edn0
  ]
  interrupt:
  [
    {
      name: uart0_tx_watermark
      width: 1
      type: interrupt
      module_name: uart0
      intr_type: IntrType.Status
      default_val: true
    }
    {
      name: uart0_rx_watermark
      width: 1
      type: interrupt
      module_name: uart0
      intr_type: IntrType.Status
      default_val: false
    }
    {
      name: uart0_tx_done
      width: 1
      type: interrupt
      module_name: uart0
      intr_type: IntrType.Event
      default_val: false
    }
    {
      name: uart0_rx_overflow
      width: 1
      type: interrupt
      module_name: uart0
      intr_type: IntrType.Event
      default_val: false
    }
    {
      name: uart0_rx_frame_err
      width: 1
      type: interrupt
      module_name: uart0
      intr_type: IntrType.Event
      default_val: false
    }
    {
      name: uart0_rx_break_err
      width: 1
      type: interrupt
      module_name: uart0
      intr_type: IntrType.Event
      default_val: false
    }
    {
      name: uart0_rx_timeout
      width: 1
      type: interrupt
      module_name: uart0
      intr_type: IntrType.Event
      default_val: false
    }
    {
      name: uart0_rx_parity_err
      width: 1
      type: interrupt
      module_name: uart0
      intr_type: IntrType.Event
      default_val: false
    }
    {
      name: uart0_tx_empty
      width: 1
      type: interrupt
      module_name: uart0
      intr_type: IntrType.Status
      default_val: true
    }
    {
      name: gpio_gpio
      width: 32
      type: interrupt
      module_name: gpio
      intr_type: IntrType.Event
      default_val: false
    }
    {
      name: spi_device_upload_cmdfifo_not_empty
      width: 1
      type: interrupt
      module_name: spi_device
      intr_type: IntrType.Event
      default_val: false
    }
    {
      name: spi_device_upload_payload_not_empty
      width: 1
      type: interrupt
      module_name: spi_device
      intr_type: IntrType.Event
      default_val: false
    }
    {
      name: spi_device_upload_payload_overflow
      width: 1
      type: interrupt
      module_name: spi_device
      intr_type: IntrType.Event
      default_val: false
    }
    {
      name: spi_device_readbuf_watermark
      width: 1
      type: interrupt
      module_name: spi_device
      intr_type: IntrType.Event
      default_val: false
    }
    {
      name: spi_device_readbuf_flip
      width: 1
      type: interrupt
      module_name: spi_device
      intr_type: IntrType.Event
      default_val: false
    }
    {
      name: spi_device_tpm_header_not_empty
      width: 1
      type: interrupt
      module_name: spi_device
      intr_type: IntrType.Status
      default_val: false
    }
    {
      name: spi_device_tpm_rdfifo_cmd_end
      width: 1
      type: interrupt
      module_name: spi_device
      intr_type: IntrType.Event
      default_val: false
    }
    {
      name: spi_device_tpm_rdfifo_drop
      width: 1
      type: interrupt
      module_name: spi_device
      intr_type: IntrType.Event
      default_val: false
    }
    {
      name: i2c0_fmt_threshold
      width: 1
      type: interrupt
      module_name: i2c0
      intr_type: IntrType.Status
      default_val: false
    }
    {
      name: i2c0_rx_threshold
      width: 1
      type: interrupt
      module_name: i2c0
      intr_type: IntrType.Status
      default_val: false
    }
    {
      name: i2c0_acq_threshold
      width: 1
      type: interrupt
      module_name: i2c0
      intr_type: IntrType.Status
      default_val: false
    }
    {
      name: i2c0_rx_overflow
      width: 1
      type: interrupt
      module_name: i2c0
      intr_type: IntrType.Event
      default_val: false
    }
    {
      name: i2c0_controller_halt
      width: 1
      type: interrupt
      module_name: i2c0
      intr_type: IntrType.Status
      default_val: false
    }
    {
      name: i2c0_scl_interference
      width: 1
      type: interrupt
      module_name: i2c0
      intr_type: IntrType.Event
      default_val: false
    }
    {
      name: i2c0_sda_interference
      width: 1
      type: interrupt
      module_name: i2c0
      intr_type: IntrType.Event
      default_val: false
    }
    {
      name: i2c0_stretch_timeout
      width: 1
      type: interrupt
      module_name: i2c0
      intr_type: IntrType.Event
      default_val: false
    }
    {
      name: i2c0_sda_unstable
      width: 1
      type: interrupt
      module_name: i2c0
      intr_type: IntrType.Event
      default_val: false
    }
    {
      name: i2c0_cmd_complete
      width: 1
      type: interrupt
      module_name: i2c0
      intr_type: IntrType.Event
      default_val: false
    }
    {
      name: i2c0_tx_stretch
      width: 1
      type: interrupt
      module_name: i2c0
      intr_type: IntrType.Status
      default_val: false
    }
    {
      name: i2c0_tx_threshold
      width: 1
      type: interrupt
      module_name: i2c0
      intr_type: IntrType.Status
      default_val: false
    }
    {
      name: i2c0_acq_stretch
      width: 1
      type: interrupt
      module_name: i2c0
      intr_type: IntrType.Status
      default_val: false
    }
    {
      name: i2c0_unexp_stop
      width: 1
      type: interrupt
      module_name: i2c0
      intr_type: IntrType.Event
      default_val: false
    }
    {
      name: i2c0_host_timeout
      width: 1
      type: interrupt
      module_name: i2c0
      intr_type: IntrType.Event
      default_val: false
    }
    {
      name: rv_timer_timer_expired_hart0_timer0
      width: 1
      type: interrupt
      module_name: rv_timer
      intr_type: IntrType.Event
      default_val: false
    }
    {
      name: kmac_kmac_done
      width: 1
      type: interrupt
      module_name: kmac
      intr_type: IntrType.Event
      default_val: false
    }
    {
      name: kmac_fifo_empty
      width: 1
      type: interrupt
      module_name: kmac
      intr_type: IntrType.Status
      default_val: false
    }
    {
      name: kmac_kmac_err
      width: 1
      type: interrupt
      module_name: kmac
      intr_type: IntrType.Event
      default_val: false
    }
    {
      name: otp_ctrl_otp_operation_done
      width: 1
      type: interrupt
      module_name: otp_ctrl
      intr_type: IntrType.Event
      default_val: false
    }
    {
      name: otp_ctrl_otp_error
      width: 1
      type: interrupt
      module_name: otp_ctrl
      intr_type: IntrType.Event
      default_val: false
    }
    {
      name: alert_handler_classa
      width: 1
      type: interrupt
      module_name: alert_handler
      intr_type: IntrType.Event
      default_val: false
    }
    {
      name: alert_handler_classb
      width: 1
      type: interrupt
      module_name: alert_handler
      intr_type: IntrType.Event
      default_val: false
    }
    {
      name: alert_handler_classc
      width: 1
      type: interrupt
      module_name: alert_handler
      intr_type: IntrType.Event
      default_val: false
    }
    {
      name: alert_handler_classd
      width: 1
      type: interrupt
      module_name: alert_handler
      intr_type: IntrType.Event
      default_val: false
    }
    {
      name: spi_host0_error
      width: 1
      type: interrupt
      module_name: spi_host0
      intr_type: IntrType.Event
      default_val: false
    }
    {
      name: spi_host0_spi_event
      width: 1
      type: interrupt
      module_name: spi_host0
      intr_type: IntrType.Status
      default_val: false
    }
    {
      name: pwrmgr_aon_wakeup
      width: 1
      type: interrupt
      module_name: pwrmgr_aon
      intr_type: IntrType.Event
      default_val: false
    }
    {
      name: aon_timer_aon_wkup_timer_expired
      width: 1
      type: interrupt
      module_name: aon_timer_aon
      intr_type: IntrType.Event
      default_val: false
    }
    {
      name: aon_timer_aon_wdog_timer_bark
      width: 1
      type: interrupt
      module_name: aon_timer_aon
      intr_type: IntrType.Event
      default_val: false
    }
    {
      name: flash_ctrl_prog_empty
      width: 1
      type: interrupt
      module_name: flash_ctrl
      intr_type: IntrType.Status
      default_val: true
    }
    {
      name: flash_ctrl_prog_lvl
      width: 1
      type: interrupt
      module_name: flash_ctrl
      intr_type: IntrType.Status
      default_val: true
    }
    {
      name: flash_ctrl_rd_full
      width: 1
      type: interrupt
      module_name: flash_ctrl
      intr_type: IntrType.Status
      default_val: false
    }
    {
      name: flash_ctrl_rd_lvl
      width: 1
      type: interrupt
      module_name: flash_ctrl
      intr_type: IntrType.Status
      default_val: false
    }
    {
      name: flash_ctrl_op_done
      width: 1
      type: interrupt
      module_name: flash_ctrl
      intr_type: IntrType.Event
      default_val: false
    }
    {
      name: flash_ctrl_corr_err
      width: 1
      type: interrupt
      module_name: flash_ctrl
      intr_type: IntrType.Event
      default_val: false
    }
    {
      name: keymgr_op_done
      width: 1
      type: interrupt
      module_name: keymgr
      intr_type: IntrType.Event
      default_val: false
    }
    {
      name: csrng_cs_cmd_req_done
      width: 1
      type: interrupt
      module_name: csrng
      intr_type: IntrType.Event
      default_val: false
    }
    {
      name: csrng_cs_entropy_req
      width: 1
      type: interrupt
      module_name: csrng
      intr_type: IntrType.Event
      default_val: false
    }
    {
      name: csrng_cs_hw_inst_exc
      width: 1
      type: interrupt
      module_name: csrng
      intr_type: IntrType.Event
      default_val: false
    }
    {
      name: csrng_cs_fatal_err
      width: 1
      type: interrupt
      module_name: csrng
      intr_type: IntrType.Event
      default_val: false
    }
    {
      name: entropy_src_es_entropy_valid
      width: 1
      type: interrupt
      module_name: entropy_src
      intr_type: IntrType.Event
      default_val: false
    }
    {
      name: entropy_src_es_health_test_failed
      width: 1
      type: interrupt
      module_name: entropy_src
      intr_type: IntrType.Event
      default_val: false
    }
    {
      name: entropy_src_es_observe_fifo_ready
      width: 1
      type: interrupt
      module_name: entropy_src
      intr_type: IntrType.Event
      default_val: false
    }
    {
      name: entropy_src_es_fatal_err
      width: 1
      type: interrupt
      module_name: entropy_src
      intr_type: IntrType.Event
      default_val: false
    }
    {
      name: edn0_edn_cmd_req_done
      width: 1
      type: interrupt
      module_name: edn0
      intr_type: IntrType.Event
      default_val: false
    }
    {
      name: edn0_edn_fatal_err
      width: 1
      type: interrupt
      module_name: edn0
      intr_type: IntrType.Event
      default_val: false
    }
  ]
  alert_module:
  [
    uart0
    gpio
    spi_device
    i2c0
    rv_timer
    kmac
    otp_ctrl
    lc_ctrl
    spi_host0
    pwrmgr_aon
    rstmgr_aon
    clkmgr_aon
    pinmux_aon
    aon_timer_aon
    sram_ctrl_ret_aon
    flash_ctrl
    rv_dm
    rv_plic
    keymgr
    csrng
    entropy_src
    edn0
    sram_ctrl_main
    rom_ctrl
    rv_core_ibex
  ]
  alert:
  [
    {
      name: uart0_fatal_fault
      width: 1
      type: alert
      async: "1"
      module_name: uart0
      lpg_name: peri_lc_io_div4_0
      lpg_idx: 0
    }
    {
      name: gpio_fatal_fault
      width: 1
      type: alert
      async: "1"
      module_name: gpio
      lpg_name: peri_lc_io_div4_0
      lpg_idx: 0
    }
    {
      name: spi_device_fatal_fault
      width: 1
      type: alert
      async: "1"
      module_name: spi_device
      lpg_name: peri_spi_device_0
      lpg_idx: 1
    }
    {
      name: i2c0_fatal_fault
      width: 1
      type: alert
      async: "1"
      module_name: i2c0
      lpg_name: peri_i2c0_0
      lpg_idx: 2
    }
    {
      name: rv_timer_fatal_fault
      width: 1
      type: alert
      async: "1"
      module_name: rv_timer
      lpg_name: timers_lc_io_div4_0
      lpg_idx: 3
    }
    {
      name: kmac_recov_operation_err
      width: 1
      type: alert
      async: "1"
      module_name: kmac
      lpg_name: kmac_trans_lc_0
      lpg_idx: 4
    }
    {
      name: kmac_fatal_fault_err
      width: 1
      type: alert
      async: "1"
      module_name: kmac
      lpg_name: kmac_trans_lc_0
      lpg_idx: 4
    }
    {
      name: otp_ctrl_fatal_macro_error
      width: 1
      type: alert
      async: "1"
      module_name: otp_ctrl
      lpg_name: secure_lc_io_div4_0
      lpg_idx: 5
    }
    {
      name: otp_ctrl_fatal_check_error
      width: 1
      type: alert
      async: "1"
      module_name: otp_ctrl
      lpg_name: secure_lc_io_div4_0
      lpg_idx: 5
    }
    {
      name: otp_ctrl_fatal_bus_integ_error
      width: 1
      type: alert
      async: "1"
      module_name: otp_ctrl
      lpg_name: secure_lc_io_div4_0
      lpg_idx: 5
    }
    {
      name: otp_ctrl_fatal_prim_otp_alert
      width: 1
      type: alert
      async: "1"
      module_name: otp_ctrl
      lpg_name: secure_lc_io_div4_0
      lpg_idx: 5
    }
    {
      name: otp_ctrl_recov_prim_otp_alert
      width: 1
      type: alert
      async: "1"
      module_name: otp_ctrl
      lpg_name: secure_lc_io_div4_0
      lpg_idx: 5
    }
    {
      name: lc_ctrl_fatal_prog_error
      width: 1
      type: alert
      async: "1"
      module_name: lc_ctrl
      lpg_name: secure_lc_io_div4_0
      lpg_idx: 5
    }
    {
      name: lc_ctrl_fatal_state_error
      width: 1
      type: alert
      async: "1"
      module_name: lc_ctrl
      lpg_name: secure_lc_io_div4_0
      lpg_idx: 5
    }
    {
      name: lc_ctrl_fatal_bus_integ_error
      width: 1
      type: alert
      async: "1"
      module_name: lc_ctrl
      lpg_name: secure_lc_io_div4_0
      lpg_idx: 5
    }
    {
      name: spi_host0_fatal_fault
      width: 1
      type: alert
      async: "1"
      module_name: spi_host0
      lpg_name: peri_spi_host0_0
      lpg_idx: 6
    }
    {
      name: pwrmgr_aon_fatal_fault
      width: 1
      type: alert
      async: "1"
      module_name: pwrmgr_aon
      lpg_name: powerup_por_io_div4_Aon
      lpg_idx: 7
    }
    {
      name: rstmgr_aon_fatal_fault
      width: 1
      type: alert
      async: "1"
      module_name: rstmgr_aon
      lpg_name: powerup_lc_io_div4_Aon
      lpg_idx: 8
    }
    {
      name: rstmgr_aon_fatal_cnsty_fault
      width: 1
      type: alert
      async: "1"
      module_name: rstmgr_aon
      lpg_name: powerup_lc_io_div4_Aon
      lpg_idx: 8
    }
    {
      name: clkmgr_aon_recov_fault
      width: 1
      type: alert
      async: "1"
      module_name: clkmgr_aon
      lpg_name: powerup_lc_io_div4_Aon
      lpg_idx: 8
    }
    {
      name: clkmgr_aon_fatal_fault
      width: 1
      type: alert
      async: "1"
      module_name: clkmgr_aon
      lpg_name: powerup_lc_io_div4_Aon
      lpg_idx: 8
    }
    {
      name: pinmux_aon_fatal_fault
      width: 1
      type: alert
      async: "1"
      module_name: pinmux_aon
      lpg_name: powerup_lc_io_div4_Aon
      lpg_idx: 8
    }
    {
      name: aon_timer_aon_fatal_fault
      width: 1
      type: alert
      async: "1"
      module_name: aon_timer_aon
      lpg_name: timers_lc_io_div4_Aon
      lpg_idx: 9
    }
    {
      name: sram_ctrl_ret_aon_fatal_error
      width: 1
      type: alert
      async: "1"
      module_name: sram_ctrl_ret_aon
      lpg_name: infra_lc_io_div4_Aon
      lpg_idx: 11
    }
    {
      name: flash_ctrl_recov_err
      width: 1
      type: alert
      async: "1"
      module_name: flash_ctrl
      lpg_name: infra_lc_0
      lpg_idx: 12
    }
    {
      name: flash_ctrl_fatal_std_err
      width: 1
      type: alert
      async: "1"
      module_name: flash_ctrl
      lpg_name: infra_lc_0
      lpg_idx: 12
    }
    {
      name: flash_ctrl_fatal_err
      width: 1
      type: alert
      async: "1"
      module_name: flash_ctrl
      lpg_name: infra_lc_0
      lpg_idx: 12
    }
    {
      name: flash_ctrl_fatal_prim_flash_alert
      width: 1
      type: alert
      async: "1"
      module_name: flash_ctrl
      lpg_name: infra_lc_0
      lpg_idx: 12
    }
    {
      name: flash_ctrl_recov_prim_flash_alert
      width: 1
      type: alert
      async: "1"
      module_name: flash_ctrl
      lpg_name: infra_lc_0
      lpg_idx: 12
    }
    {
      name: rv_dm_fatal_fault
      width: 1
      type: alert
      async: "1"
      module_name: rv_dm
      lpg_name: infra_sys_0
      lpg_idx: 13
    }
    {
      name: rv_plic_fatal_fault
      width: 1
      type: alert
      async: "1"
      module_name: rv_plic
      lpg_name: secure_lc_0
      lpg_idx: 14
    }
    {
      name: keymgr_recov_operation_err
      width: 1
      type: alert
      async: "1"
      module_name: keymgr
      lpg_name: secure_lc_0
      lpg_idx: 14
    }
    {
      name: keymgr_fatal_fault_err
      width: 1
      type: alert
      async: "1"
      module_name: keymgr
      lpg_name: secure_lc_0
      lpg_idx: 14
    }
    {
      name: csrng_recov_alert
      width: 1
      type: alert
      async: "1"
      module_name: csrng
      lpg_name: secure_lc_0
      lpg_idx: 14
    }
    {
      name: csrng_fatal_alert
      width: 1
      type: alert
      async: "1"
      module_name: csrng
      lpg_name: secure_lc_0
      lpg_idx: 14
    }
    {
      name: entropy_src_recov_alert
      width: 1
      type: alert
      async: "1"
      module_name: entropy_src
      lpg_name: secure_lc_0
      lpg_idx: 14
    }
    {
      name: entropy_src_fatal_alert
      width: 1
      type: alert
      async: "1"
      module_name: entropy_src
      lpg_name: secure_lc_0
      lpg_idx: 14
    }
    {
      name: edn0_recov_alert
      width: 1
      type: alert
      async: "1"
      module_name: edn0
      lpg_name: secure_lc_0
      lpg_idx: 14
    }
    {
      name: edn0_fatal_alert
      width: 1
      type: alert
      async: "1"
      module_name: edn0
      lpg_name: secure_lc_0
      lpg_idx: 14
    }
    {
      name: sram_ctrl_main_fatal_error
      width: 1
      type: alert
      async: "1"
      module_name: sram_ctrl_main
      lpg_name: infra_lc_0
      lpg_idx: 12
    }
    {
      name: rom_ctrl_fatal
      width: 1
      type: alert
      async: "1"
      module_name: rom_ctrl
      lpg_name: infra_lc_0
      lpg_idx: 12
    }
    {
      name: rv_core_ibex_fatal_sw_err
      width: 1
      type: alert
      async: "1"
      module_name: rv_core_ibex
      lpg_name: infra_lc_0
      lpg_idx: 12
    }
    {
      name: rv_core_ibex_recov_sw_err
      width: 1
      type: alert
      async: "1"
      module_name: rv_core_ibex
      lpg_name: infra_lc_0
      lpg_idx: 12
    }
    {
      name: rv_core_ibex_fatal_hw_err
      width: 1
      type: alert
      async: "1"
      module_name: rv_core_ibex
      lpg_name: infra_lc_0
      lpg_idx: 12
    }
    {
      name: rv_core_ibex_recov_hw_err
      width: 1
      type: alert
      async: "1"
      module_name: rv_core_ibex
      lpg_name: infra_lc_0
      lpg_idx: 12
    }
  ]
  exported_rsts: {}
  alert_lpgs:
  [
    {
      name: peri_lc_io_div4_0
      clock_group:
      {
        name: peri
        src: top
        sw_cg: yes
        unique: no
        clocks:
        {
          clk_io_div4_peri: io_div4
          clk_io_div2_peri: io_div2
          clk_exp_peri: exp
          clk_exp_div2_peri: exp_div2
          clk_exp_div8_peri: exp_div8
          clk_main_div2_peri: main_div2
          clk_main_div10_peri: main_div10
          clk_usb_div4_peri: usb_div4
          clk_main_peri: main
          clk_usb_peri: usb
          clk_exp2_peri: exp2
          clk_exp2_div2_peri: exp2_div2
          clk_exp2_div6_peri: exp2_div6
          clk_io_peri: io
          clk_aon_peri: aon
        }
      }
      clock_connection: clkmgr_aon_clocks.clk_io_div4_peri
      reset_connection:
      {
        name: lc_io_div4
        domain: "0"
      }
    }
    {
      name: peri_spi_device_0
      clock_group:
      {
        name: peri
        src: top
        sw_cg: yes
        unique: no
        clocks:
        {
          clk_io_div4_peri: io_div4
          clk_io_div2_peri: io_div2
          clk_exp_peri: exp
          clk_exp_div2_peri: exp_div2
          clk_exp_div8_peri: exp_div8
          clk_main_div2_peri: main_div2
          clk_main_div10_peri: main_div10
          clk_usb_div4_peri: usb_div4
          clk_main_peri: main
          clk_usb_peri: usb
          clk_exp2_peri: exp2
          clk_exp2_div2_peri: exp2_div2
          clk_exp2_div6_peri: exp2_div6
          clk_io_peri: io
          clk_aon_peri: aon
        }
      }
      clock_connection: clkmgr_aon_clocks.clk_io_div4_peri
      reset_connection:
      {
        name: spi_device
        domain: "0"
      }
    }
    {
      name: peri_i2c0_0
      clock_group:
      {
        name: peri
        src: top
        sw_cg: yes
        unique: no
        clocks:
        {
          clk_io_div4_peri: io_div4
          clk_io_div2_peri: io_div2
          clk_exp_peri: exp
          clk_exp_div2_peri: exp_div2
          clk_exp_div8_peri: exp_div8
          clk_main_div2_peri: main_div2
          clk_main_div10_peri: main_div10
          clk_usb_div4_peri: usb_div4
          clk_main_peri: main
          clk_usb_peri: usb
          clk_exp2_peri: exp2
          clk_exp2_div2_peri: exp2_div2
          clk_exp2_div6_peri: exp2_div6
          clk_io_peri: io
          clk_aon_peri: aon
        }
      }
      clock_connection: clkmgr_aon_clocks.clk_io_div4_peri
      reset_connection:
      {
        name: i2c0
        domain: "0"
      }
    }
    {
      name: timers_lc_io_div4_0
      clock_group:
      {
        name: timers
        src: top
        sw_cg: no
        unique: no
        clocks:
        {
          clk_io_div4_timers: io_div4
          clk_aon_timers: aon
        }
      }
      clock_connection: clkmgr_aon_clocks.clk_io_div4_timers
      reset_connection:
      {
        name: lc_io_div4
        domain: "0"
      }
    }
    {
      name: kmac_trans_lc_0
      clock_group:
      {
        name: trans
        src: top
        sw_cg: hint
        unique: yes
        clocks:
        {
          clk_main_kmac: main
        }
      }
      clock_connection: clkmgr_aon_clocks.clk_main_kmac
      reset_connection:
      {
        name: lc
        domain: "0"
      }
    }
    {
      name: secure_lc_io_div4_0
      clock_group:
      {
        name: secure
        src: top
        sw_cg: no
        unique: no
        clocks:
        {
          clk_io_div4_secure: io_div4
          clk_main_secure: main
        }
      }
      clock_connection: clkmgr_aon_clocks.clk_io_div4_secure
      reset_connection:
      {
        name: lc_io_div4
        domain: "0"
      }
    }
    {
      name: peri_spi_host0_0
      clock_group:
      {
        name: peri
        src: top
        sw_cg: yes
        unique: no
        clocks:
        {
          clk_io_div4_peri: io_div4
          clk_io_div2_peri: io_div2
          clk_exp_peri: exp
          clk_exp_div2_peri: exp_div2
          clk_exp_div8_peri: exp_div8
          clk_main_div2_peri: main_div2
          clk_main_div10_peri: main_div10
          clk_usb_div4_peri: usb_div4
          clk_main_peri: main
          clk_usb_peri: usb
          clk_exp2_peri: exp2
          clk_exp2_div2_peri: exp2_div2
          clk_exp2_div6_peri: exp2_div6
          clk_io_peri: io
          clk_aon_peri: aon
        }
      }
      clock_connection: clkmgr_aon_clocks.clk_io_peri
      reset_connection:
      {
        name: spi_host0
        domain: "0"
      }
    }
    {
      name: powerup_por_io_div4_Aon
      clock_group:
      {
        name: powerup
        src: top
        sw_cg: no
        unique: no
        clocks:
        {
          clk_io_div4_powerup: io_div4
          clk_aon_powerup: aon
          clk_main_powerup: main
          clk_io_powerup: io
          clk_usb_powerup: usb
          clk_io_div2_powerup: io_div2
          clk_exp_powerup: exp
          clk_main_div2_powerup: main_div2
          clk_main_div10_powerup: main_div10
          clk_usb_div4_powerup: usb_div4
          clk_exp_div2_powerup: exp_div2
          clk_exp_div8_powerup: exp_div8
          clk_exp2_powerup: exp2
          clk_exp2_div2_powerup: exp2_div2
          clk_exp2_div6_powerup: exp2_div6
        }
      }
      clock_connection: clkmgr_aon_clocks.clk_io_div4_powerup
      reset_connection:
      {
        name: por_io_div4
        domain: Aon
      }
    }
    {
      name: powerup_lc_io_div4_Aon
      clock_group:
      {
        name: powerup
        src: top
        sw_cg: no
        unique: no
        clocks:
        {
          clk_io_div4_powerup: io_div4
          clk_aon_powerup: aon
          clk_main_powerup: main
          clk_io_powerup: io
          clk_usb_powerup: usb
          clk_io_div2_powerup: io_div2
          clk_exp_powerup: exp
          clk_main_div2_powerup: main_div2
          clk_main_div10_powerup: main_div10
          clk_usb_div4_powerup: usb_div4
          clk_exp_div2_powerup: exp_div2
          clk_exp_div8_powerup: exp_div8
          clk_exp2_powerup: exp2
          clk_exp2_div2_powerup: exp2_div2
          clk_exp2_div6_powerup: exp2_div6
        }
      }
      clock_connection: clkmgr_aon_clocks.clk_io_div4_powerup
      reset_connection:
      {
        name: lc_io_div4
        domain: Aon
      }
    }
    {
      name: timers_lc_io_div4_Aon
      clock_group:
      {
        name: timers
        src: top
        sw_cg: no
        unique: no
        clocks:
        {
          clk_io_div4_timers: io_div4
          clk_aon_timers: aon
        }
      }
      clock_connection: clkmgr_aon_clocks.clk_io_div4_timers
      reset_connection:
      {
        name: lc_io_div4
        domain: Aon
      }
    }
    {
      name: infra_lc_io_div4_0
      clock_group:
      {
        name: infra
        src: top
        sw_cg: no
        unique: no
        clocks:
        {
          clk_io_div4_infra: io_div4
          clk_main_infra: main
          clk_io_infra: io
        }
      }
      clock_connection: clkmgr_aon_clocks.clk_io_div4_infra
      reset_connection:
      {
        name: lc_io_div4
        domain: "0"
      }
    }
    {
      name: infra_lc_io_div4_Aon
      clock_group:
      {
        name: infra
        src: top
        sw_cg: no
        unique: no
        clocks:
        {
          clk_io_div4_infra: io_div4
          clk_main_infra: main
          clk_io_infra: io
        }
      }
      clock_connection: clkmgr_aon_clocks.clk_io_div4_infra
      reset_connection:
      {
        name: lc_io_div4
        domain: Aon
      }
    }
    {
      name: infra_lc_0
      clock_group:
      {
        name: infra
        src: top
        sw_cg: no
        unique: no
        clocks:
        {
          clk_io_div4_infra: io_div4
          clk_main_infra: main
          clk_io_infra: io
        }
      }
      clock_connection: clkmgr_aon_clocks.clk_main_infra
      reset_connection:
      {
        name: lc
        domain: "0"
      }
    }
    {
      name: infra_sys_0
      clock_group:
      {
        name: infra
        src: top
        sw_cg: no
        unique: no
        clocks:
        {
          clk_io_div4_infra: io_div4
          clk_main_infra: main
          clk_io_infra: io
        }
      }
      clock_connection: clkmgr_aon_clocks.clk_main_infra
      reset_connection:
      {
        name: sys
        domain: "0"
      }
    }
    {
      name: secure_lc_0
      clock_group:
      {
        name: secure
        src: top
        sw_cg: no
        unique: no
        clocks:
        {
          clk_io_div4_secure: io_div4
          clk_main_secure: main
        }
      }
      clock_connection: clkmgr_aon_clocks.clk_main_secure
      reset_connection:
      {
        name: lc
        domain: "0"
      }
    }
  ]
  inter_signal:
  {
    signals:
    [
      {
        name: tl
        struct: tl
        package: tlul_pkg
        type: req_rsp
        act: rsp
        width: 1
        inst_name: uart0
        default: ""
        end_idx: -1
        top_signame: uart0_tl
        index: -1
      }
      {
        name: tl
        struct: tl
        package: tlul_pkg
        type: req_rsp
        act: rsp
        width: 1
        inst_name: gpio
        default: ""
        end_idx: -1
        top_signame: gpio_tl
        index: -1
      }
      {
        name: ram_cfg
        struct: ram_2p_cfg
        package: prim_ram_2p_pkg
        type: uni
        act: rcv
        width: 1
        inst_name: spi_device
        default: ""
        top_signame: ast_spi_ram_2p_cfg
        index: -1
      }
      {
        name: passthrough
        struct: passthrough
        package: spi_device_pkg
        type: req_rsp
        act: req
        width: 1
        inst_name: spi_device
        default: ""
        end_idx: -1
        top_signame: spi_device_passthrough
        index: -1
      }
      {
        name: mbist_en
        struct: logic
        type: uni
        act: rcv
        width: 1
        inst_name: spi_device
        index: -1
      }
      {
        name: sck_monitor
        struct: logic
        type: uni
        act: req
        width: 1
        inst_name: spi_device
        default: ""
        package: ""
        external: true
        top_signame: sck_monitor
        conn_type: false
        index: -1
      }
      {
        name: tl
        struct: tl
        package: tlul_pkg
        type: req_rsp
        act: rsp
        width: 1
        inst_name: spi_device
        default: ""
        end_idx: -1
        top_signame: spi_device_tl
        index: -1
      }
      {
        name: tl
        struct: tl
        package: tlul_pkg
        type: req_rsp
        act: rsp
        width: 1
        inst_name: ergo_cdc_bridge0
        default: ""
        end_idx: -1
        top_signame: ergo_cdc_bridge0_tl
        index: -1
      }
      {
        name: tl
        struct: tl
        package: tlul_pkg
        type: req_rsp
        act: rsp
        width: 1
        inst_name: ergo_cdc_bridge1
        default: ""
        end_idx: -1
        top_signame: ergo_cdc_bridge1_tl
        index: -1
      }
      {
        name: tl
        struct: tl
        package: tlul_pkg
        type: req_rsp
        act: rsp
        width: 1
        inst_name: ergo_cdc_bridge2
        default: ""
        end_idx: -1
        top_signame: ergo_cdc_bridge2_tl
        index: -1
      }
      {
        name: tl
        struct: tl
        package: tlul_pkg
        type: req_rsp
        act: rsp
        width: 1
        inst_name: ergo_cdc_bridge3
        default: ""
        end_idx: -1
        top_signame: ergo_cdc_bridge3_tl
        index: -1
      }
      {
        name: tl
        struct: tl
        package: tlul_pkg
        type: req_rsp
        act: rsp
        width: 1
        inst_name: ergo_cdc_bridge4
        default: ""
        end_idx: -1
        top_signame: ergo_cdc_bridge4_tl
        index: -1
      }
      {
        name: tl
        struct: tl
        package: tlul_pkg
        type: req_rsp
        act: rsp
        width: 1
        inst_name: ergo_cdc_bridge5
        default: ""
        end_idx: -1
        top_signame: ergo_cdc_bridge5_tl
        index: -1
      }
      {
        name: tl
        struct: tl
        package: tlul_pkg
        type: req_rsp
        act: rsp
        width: 1
        inst_name: ergo_setup_gen0
        default: ""
        end_idx: -1
        top_signame: ergo_setup_gen0_tl
        index: -1
      }
      {
        name: tl
        struct: tl
        package: tlul_pkg
        type: req_rsp
        act: rsp
        width: 1
        inst_name: ergo_setup_gen1
        default: ""
        end_idx: -1
        top_signame: ergo_setup_gen1_tl
        index: -1
      }
      {
        name: tl
        struct: tl
        package: tlul_pkg
        type: req_rsp
        act: rsp
        width: 1
        inst_name: ergo_setup_gen2
        default: ""
        end_idx: -1
        top_signame: ergo_setup_gen2_tl
        index: -1
      }
      {
        name: tl
        struct: tl
        package: tlul_pkg
        type: req_rsp
        act: rsp
        width: 1
        inst_name: ergo_setup_gen3
        default: ""
        end_idx: -1
        top_signame: ergo_setup_gen3_tl
        index: -1
      }
      {
        name: tl
        struct: tl
        package: tlul_pkg
        type: req_rsp
        act: rsp
        width: 1
        inst_name: ergo_setup_gen4
        default: ""
        end_idx: -1
        top_signame: ergo_setup_gen4_tl
        index: -1
      }
      {
        name: tl
        struct: tl
        package: tlul_pkg
        type: req_rsp
        act: rsp
        width: 1
        inst_name: ergo_setup_gen5
        default: ""
        end_idx: -1
        top_signame: ergo_setup_gen5_tl
        index: -1
      }
      {
        name: tl
        struct: tl
        package: tlul_pkg
        type: req_rsp
        act: rsp
        width: 1
        inst_name: ergo_hold_gen0
        default: ""
        end_idx: -1
        top_signame: ergo_hold_gen0_tl
        index: -1
      }
      {
        name: tl
        struct: tl
        package: tlul_pkg
        type: req_rsp
        act: rsp
        width: 1
        inst_name: ergo_hold_gen1
        default: ""
        end_idx: -1
        top_signame: ergo_hold_gen1_tl
        index: -1
      }
      {
        name: tl
        struct: tl
        package: tlul_pkg
        type: req_rsp
        act: rsp
        width: 1
        inst_name: ergo_hold_gen2
        default: ""
        end_idx: -1
        top_signame: ergo_hold_gen2_tl
        index: -1
      }
      {
        name: tl
        struct: tl
        package: tlul_pkg
        type: req_rsp
        act: rsp
        width: 1
        inst_name: ergo_hold_gen3
        default: ""
        end_idx: -1
        top_signame: ergo_hold_gen3_tl
        index: -1
      }
      {
        name: tl
        struct: tl
        package: tlul_pkg
        type: req_rsp
        act: rsp
        width: 1
        inst_name: ergo_hold_gen4
        default: ""
        end_idx: -1
        top_signame: ergo_hold_gen4_tl
        index: -1
      }
      {
        name: tl
        struct: tl
        package: tlul_pkg
        type: req_rsp
        act: rsp
        width: 1
        inst_name: ergo_cdc_hazard_gen0
        default: ""
        end_idx: -1
        top_signame: ergo_cdc_hazard_gen0_tl
        index: -1
      }
      {
        name: tl
        struct: tl
        package: tlul_pkg
        type: req_rsp
        act: rsp
        width: 1
        inst_name: ergo_cdc_hazard_gen1
        default: ""
        end_idx: -1
        top_signame: ergo_cdc_hazard_gen1_tl
        index: -1
      }
      {
        name: tl
        struct: tl
        package: tlul_pkg
        type: req_rsp
        act: rsp
        width: 1
        inst_name: ergo_cdc_hazard_gen2
        default: ""
        end_idx: -1
        top_signame: ergo_cdc_hazard_gen2_tl
        index: -1
      }
      {
        name: tl
        struct: tl
        package: tlul_pkg
        type: req_rsp
        act: rsp
        width: 1
        inst_name: ergo_cdc_hazard_gen3
        default: ""
        end_idx: -1
        top_signame: ergo_cdc_hazard_gen3_tl
        index: -1
      }
      {
        name: tl
        struct: tl
        package: tlul_pkg
        type: req_rsp
        act: rsp
        width: 1
        inst_name: ergo_cdc_hazard_gen4
        default: ""
        end_idx: -1
        top_signame: ergo_cdc_hazard_gen4_tl
        index: -1
      }
      {
        name: tl
        struct: tl
        package: tlul_pkg
        type: req_rsp
        act: rsp
        width: 1
        inst_name: ergo_cdc_bridge6
        default: ""
        end_idx: -1
        top_signame: ergo_cdc_bridge6_tl
        index: -1
      }
      {
        name: tl
        struct: tl
        package: tlul_pkg
        type: req_rsp
        act: rsp
        width: 1
        inst_name: ergo_cdc_bridge7
        default: ""
        end_idx: -1
        top_signame: ergo_cdc_bridge7_tl
        index: -1
      }
      {
        name: tl
        struct: tl
        package: tlul_pkg
        type: req_rsp
        act: rsp
        width: 1
        inst_name: ergo_cdc_bridge8
        default: ""
        end_idx: -1
        top_signame: ergo_cdc_bridge8_tl
        index: -1
      }
      {
        name: tl
        struct: tl
        package: tlul_pkg
        type: req_rsp
        act: rsp
        width: 1
        inst_name: ergo_setup_gen6
        default: ""
        end_idx: -1
        top_signame: ergo_setup_gen6_tl
        index: -1
      }
      {
        name: tl
        struct: tl
        package: tlul_pkg
        type: req_rsp
        act: rsp
        width: 1
        inst_name: ergo_setup_gen7
        default: ""
        end_idx: -1
        top_signame: ergo_setup_gen7_tl
        index: -1
      }
      {
        name: tl
        struct: tl
        package: tlul_pkg
        type: req_rsp
        act: rsp
        width: 1
        inst_name: ergo_setup_gen8
        default: ""
        end_idx: -1
        top_signame: ergo_setup_gen8_tl
        index: -1
      }
      {
        name: tl
        struct: tl
        package: tlul_pkg
        type: req_rsp
        act: rsp
        width: 1
        inst_name: ergo_hold_gen5
        default: ""
        end_idx: -1
        top_signame: ergo_hold_gen5_tl
        index: -1
      }
      {
        name: tl
        struct: tl
        package: tlul_pkg
        type: req_rsp
        act: rsp
        width: 1
        inst_name: ergo_hold_gen6
        default: ""
        end_idx: -1
        top_signame: ergo_hold_gen6_tl
        index: -1
      }
      {
        name: tl
        struct: tl
        package: tlul_pkg
        type: req_rsp
        act: rsp
        width: 1
        inst_name: ergo_cdc_hazard_gen5
        default: ""
        end_idx: -1
        top_signame: ergo_cdc_hazard_gen5_tl
        index: -1
      }
      {
        name: tl
        struct: tl
        package: tlul_pkg
        type: req_rsp
        act: rsp
        width: 1
        inst_name: ergo_cdc_hazard_gen6
        default: ""
        end_idx: -1
        top_signame: ergo_cdc_hazard_gen6_tl
        index: -1
      }
      {
        name: ram_cfg
        struct: ram_1p_cfg
        package: prim_ram_1p_pkg
        type: uni
        act: rcv
        width: 1
        inst_name: i2c0
        default: ""
        top_signame: ast_ram_1p_cfg
        index: -1
      }
      {
        name: tl
        struct: tl
        package: tlul_pkg
        type: req_rsp
        act: rsp
        width: 1
        inst_name: i2c0
        default: ""
        end_idx: -1
        top_signame: i2c0_tl
        index: -1
      }
      {
        name: tl
        struct: tl
        package: tlul_pkg
        type: req_rsp
        act: rsp
        width: 1
        inst_name: rv_timer
        default: ""
        end_idx: -1
        top_signame: rv_timer_tl
        index: -1
      }
      {
        name: keymgr_key
        struct: hw_key_req
        package: keymgr_pkg
        type: uni
        act: rcv
        width: 1
        inst_name: kmac
        default: ""
        top_signame: keymgr_kmac_key
        index: -1
      }
      {
        name: app
        struct: app
        package: kmac_pkg
        type: req_rsp
        act: rsp
        width: 3
        inst_name: kmac
        default: ""
        end_idx: -1
        top_type: one-to-N
        top_signame: kmac_app
        index: -1
      }
      {
        name: entropy
        struct: edn
        package: edn_pkg
        type: req_rsp
        act: req
        width: 1
        inst_name: kmac
        default: ""
        top_signame: edn0_edn
        index: 3
      }
      {
        name: idle
        struct: mubi4
        package: prim_mubi_pkg
        type: uni
        act: req
        width: 1
        inst_name: kmac
        default: ""
        top_signame: clkmgr_aon_idle
        index: -1
      }
      {
        name: en_masking
        struct: logic
        type: uni
        act: req
        width: 1
        inst_name: kmac
        default: ""
        package: ""
        end_idx: -1
        top_type: broadcast
        top_signame: kmac_en_masking
        index: -1
      }
      {
        name: lc_escalate_en
        struct: lc_tx
        package: lc_ctrl_pkg
        type: uni
        act: rcv
        width: 1
        default: lc_ctrl_pkg::Off
        inst_name: kmac
        top_signame: lc_ctrl_lc_escalate_en
        index: -1
      }
      {
        name: tl
        struct: tl
        package: tlul_pkg
        type: req_rsp
        act: rsp
        width: 1
        inst_name: kmac
        default: ""
        end_idx: -1
        top_signame: kmac_tl
        index: -1
      }
      {
        name: otp_ext_voltage_h
        struct: ""
        type: io
        act: none
        width: 1
        default: "'0"
        inst_name: otp_ctrl
        package: ""
        external: true
        top_signame: otp_ext_voltage_h
        conn_type: false
        index: -1
      }
      {
        name: otp_ast_pwr_seq
        desc: Power sequencing signals to AST (VDD domain).
        struct: otp_ast_req
        package: otp_ctrl_pkg
        type: uni
        act: req
        width: 1
        default: "'0"
        inst_name: otp_ctrl
        external: true
        top_signame: otp_ctrl_otp_ast_pwr_seq
        conn_type: false
        index: -1
      }
      {
        name: otp_ast_pwr_seq_h
        desc: Power sequencing signals coming from AST (VCC domain).
        struct: otp_ast_rsp
        package: otp_ctrl_pkg
        type: uni
        act: rcv
        width: 1
        default: "'0"
        inst_name: otp_ctrl
        external: true
        top_signame: otp_ctrl_otp_ast_pwr_seq_h
        conn_type: false
        index: -1
      }
      {
        name: edn
        desc: Entropy request to the entropy distribution network for LFSR reseeding and ephemeral key derivation.
        struct: edn
        package: edn_pkg
        type: req_rsp
        act: req
        width: 1
        inst_name: otp_ctrl
        default: ""
        top_signame: edn0_edn
        index: 1
      }
      {
        name: pwr_otp
        desc: Initialization request/acknowledge from/to power manager.
        struct: pwr_otp
        package: pwrmgr_pkg
        type: req_rsp
        act: rsp
        width: 1
        default: "'0"
        inst_name: otp_ctrl
        top_signame: pwrmgr_aon_pwr_otp
        index: -1
      }
      {
        name: lc_otp_vendor_test
        desc: Vendor test control signals from/to the life cycle TAP.
        struct: lc_otp_vendor_test
        package: otp_ctrl_pkg
        type: req_rsp
        act: rsp
        width: 1
        default: "'0"
        inst_name: otp_ctrl
        top_signame: lc_ctrl_lc_otp_vendor_test
        index: -1
      }
      {
        name: lc_otp_program
        desc: Life cycle state transition interface.
        struct: lc_otp_program
        package: otp_ctrl_pkg
        type: req_rsp
        act: rsp
        width: 1
        default: "'0"
        inst_name: otp_ctrl
        top_signame: lc_ctrl_lc_otp_program
        index: -1
      }
      {
        name: otp_lc_data
        desc:
          '''
          Life cycle state output holding the current life cycle state,
          the value of the transition counter and the tokens needed for life cycle transitions.
          '''
        struct: otp_lc_data
        package: otp_ctrl_pkg
        type: uni
        act: req
        width: 1
        default: "'0"
        inst_name: otp_ctrl
        end_idx: -1
        top_type: broadcast
        top_signame: otp_ctrl_otp_lc_data
        index: -1
      }
      {
        name: lc_escalate_en
        desc:
          '''
          Life cycle escalation enable coming from life cycle controller.
          This signal moves all FSMs within OTP into the error state.
          '''
        struct: lc_tx
        package: lc_ctrl_pkg
        type: uni
        act: rcv
        width: 1
        default: lc_ctrl_pkg::Off
        inst_name: otp_ctrl
        top_signame: lc_ctrl_lc_escalate_en
        index: -1
      }
      {
        name: lc_creator_seed_sw_rw_en
        desc:
          '''
          Provision enable qualifier coming from life cycle controller.
          This signal enables SW read / write access to the RMA_TOKEN and CREATOR_ROOT_KEY_SHARE0 and CREATOR_ROOT_KEY_SHARE1.
          '''
        struct: lc_tx
        package: lc_ctrl_pkg
        type: uni
        act: rcv
        width: 1
        default: lc_ctrl_pkg::Off
        inst_name: otp_ctrl
        top_signame: lc_ctrl_lc_creator_seed_sw_rw_en
        index: -1
      }
      {
        name: lc_owner_seed_sw_rw_en
        desc:
          '''
          Provision enable qualifier coming from life cycle controller.
          This signal enables SW read / write access to the OWNER_SEED.
          '''
        struct: lc_tx
        package: lc_ctrl_pkg
        type: uni
        act: rcv
        width: 1
        default: lc_ctrl_pkg::Off
        inst_name: otp_ctrl
        index: -1
      }
      {
        name: lc_seed_hw_rd_en
        desc:
          '''
          Seed read enable coming from life cycle controller.
          This signal enables HW read access to the CREATOR_ROOT_KEY_SHARE0 and CREATOR_ROOT_KEY_SHARE1.
          '''
        struct: lc_tx
        package: lc_ctrl_pkg
        type: uni
        act: rcv
        width: 1
        default: lc_ctrl_pkg::Off
        inst_name: otp_ctrl
        top_signame: lc_ctrl_lc_seed_hw_rd_en
        index: -1
      }
      {
        name: lc_dft_en
        desc:
          '''
          Test enable qualifier coming from life cycle controller.
          This signals enables the TL-UL access port to the proprietary OTP IP.
          '''
        struct: lc_tx
        package: lc_ctrl_pkg
        type: uni
        act: rcv
        width: 1
        default: lc_ctrl_pkg::Off
        inst_name: otp_ctrl
        top_signame: lc_ctrl_lc_dft_en
        index: -1
      }
      {
        name: lc_check_byp_en
        desc:
          '''
          Life cycle partition check bypass signal.
          This signal causes the life cycle partition to bypass consistency checks during life cycle state transitions in order to prevent spurious consistency check failures.
          '''
        struct: lc_tx
        package: lc_ctrl_pkg
        type: uni
        act: rcv
        width: 1
        default: lc_ctrl_pkg::Off
        inst_name: otp_ctrl
        top_signame: lc_ctrl_lc_check_byp_en
        index: -1
      }
      {
        name: otp_keymgr_key
        desc: Key output to the key manager holding CREATOR_ROOT_KEY_SHARE0 and CREATOR_ROOT_KEY_SHARE1.
        struct: otp_keymgr_key
        package: otp_ctrl_pkg
        type: uni
        act: req
        width: 1
        default: "'0"
        inst_name: otp_ctrl
        end_idx: -1
        top_type: broadcast
        top_signame: otp_ctrl_otp_keymgr_key
        index: -1
      }
      {
        name: flash_otp_key
        desc: Key derivation interface for FLASH scrambling.
        struct: flash_otp_key
        package: otp_ctrl_pkg
        type: req_rsp
        act: rsp
        width: 1
        default: "'0"
        inst_name: otp_ctrl
        top_signame: flash_ctrl_otp
        index: -1
      }
      {
        name: sram_otp_key
        desc: Array with key derivation interfaces for SRAM scrambling devices.
        struct: sram_otp_key
        package: otp_ctrl_pkg
        type: req_rsp
        act: rsp
        width: 4
        default: "'0"
        inst_name: otp_ctrl
        end_idx: 3
        top_type: partial-one-to-N
        top_signame: otp_ctrl_sram_otp_key
        index: -1
      }
      {
        name: otbn_otp_key
        desc: Key derivation interface for OTBN scrambling devices.
        struct: otbn_otp_key
        package: otp_ctrl_pkg
        type: req_rsp
        act: rsp
        width: 1
        default: "'0"
        inst_name: otp_ctrl
        index: -1
      }
      {
        name: otp_broadcast
        desc: Output of the HW partitions with breakout data types.
        struct: otp_broadcast
        package: otp_ctrl_part_pkg
        type: uni
        act: req
        width: 1
        default: "'0"
        inst_name: otp_ctrl
        top_signame: otp_ctrl_otp_broadcast
        index: -1
      }
      {
        name: obs_ctrl
        desc: AST observability control signals.
        struct: ast_obs_ctrl
        package: ast_pkg
        type: uni
        act: rcv
        width: 1
        inst_name: otp_ctrl
        default: ""
        top_signame: ast_obs_ctrl
        index: -1
      }
      {
        name: otp_obs
        desc: AST observability bus.
        struct: logic
        type: uni
        act: req
        width: 8
        inst_name: otp_ctrl
        default: ""
        package: ""
        external: true
        top_signame: otp_obs
        conn_type: false
        index: -1
      }
      {
        name: core_tl
        struct: tl
        package: tlul_pkg
        type: req_rsp
        act: rsp
        width: 1
        inst_name: otp_ctrl
        default: ""
        end_idx: -1
        top_signame: otp_ctrl_core_tl
        index: -1
      }
      {
        name: prim_tl
        struct: tl
        package: tlul_pkg
        type: req_rsp
        act: rsp
        width: 1
        inst_name: otp_ctrl
        default: ""
        end_idx: -1
        top_signame: otp_ctrl_prim_tl
        index: -1
      }
      {
        name: jtag
        struct: jtag
        package: jtag_pkg
        type: req_rsp
        act: rsp
        width: 1
        inst_name: lc_ctrl
        default: ""
        top_signame: pinmux_aon_lc_jtag
        index: -1
      }
      {
        name: esc_scrap_state0_tx
        struct: esc_tx
        package: prim_esc_pkg
        type: uni
        act: rcv
        width: 1
        inst_name: lc_ctrl
        default: ""
        top_signame: alert_handler_esc_tx
        index: 1
      }
      {
        name: esc_scrap_state0_rx
        struct: esc_rx
        package: prim_esc_pkg
        type: uni
        act: req
        width: 1
        inst_name: lc_ctrl
        default: ""
        top_signame: alert_handler_esc_rx
        index: 1
      }
      {
        name: esc_scrap_state1_tx
        struct: esc_tx
        package: prim_esc_pkg
        type: uni
        act: rcv
        width: 1
        inst_name: lc_ctrl
        default: ""
        top_signame: alert_handler_esc_tx
        index: 2
      }
      {
        name: esc_scrap_state1_rx
        struct: esc_rx
        package: prim_esc_pkg
        type: uni
        act: req
        width: 1
        inst_name: lc_ctrl
        default: ""
        top_signame: alert_handler_esc_rx
        index: 2
      }
      {
        name: pwr_lc
        struct: pwr_lc
        package: pwrmgr_pkg
        type: req_rsp
        act: rsp
        width: 1
        inst_name: lc_ctrl
        default: ""
        top_signame: pwrmgr_aon_pwr_lc
        index: -1
      }
      {
        name: lc_otp_vendor_test
        struct: lc_otp_vendor_test
        package: otp_ctrl_pkg
        type: req_rsp
        act: req
        width: 1
        default: "'0"
        inst_name: lc_ctrl
        end_idx: -1
        top_signame: lc_ctrl_lc_otp_vendor_test
        index: -1
      }
      {
        name: otp_lc_data
        struct: otp_lc_data
        package: otp_ctrl_pkg
        type: uni
        act: rcv
        width: 1
        default: otp_ctrl_pkg::OTP_LC_DATA_DEFAULT
        inst_name: lc_ctrl
        top_signame: otp_ctrl_otp_lc_data
        index: -1
      }
      {
        name: lc_otp_program
        struct: lc_otp_program
        package: otp_ctrl_pkg
        type: req_rsp
        act: req
        width: 1
        default: "'0"
        inst_name: lc_ctrl
        end_idx: -1
        top_signame: lc_ctrl_lc_otp_program
        index: -1
      }
      {
        name: kmac_data
        struct: app
        package: kmac_pkg
        type: req_rsp
        act: req
        width: 1
        default: "'0"
        inst_name: lc_ctrl
        top_signame: kmac_app
        index: 1
      }
      {
        name: lc_dft_en
        struct: lc_tx
        package: lc_ctrl_pkg
        type: uni
        act: req
        width: 1
        default: lc_ctrl_pkg::Off
        inst_name: lc_ctrl
        end_idx: -1
        top_type: broadcast
        top_signame: lc_ctrl_lc_dft_en
        index: -1
      }
      {
        name: lc_nvm_debug_en
        struct: lc_tx
        package: lc_ctrl_pkg
        type: uni
        act: req
        width: 1
        default: lc_ctrl_pkg::Off
        inst_name: lc_ctrl
        end_idx: -1
        top_type: broadcast
        top_signame: lc_ctrl_lc_nvm_debug_en
        index: -1
      }
      {
        name: lc_hw_debug_en
        struct: lc_tx
        package: lc_ctrl_pkg
        type: uni
        act: req
        width: 1
        default: lc_ctrl_pkg::Off
        inst_name: lc_ctrl
        end_idx: -1
        top_type: broadcast
        top_signame: lc_ctrl_lc_hw_debug_en
        index: -1
      }
      {
        name: lc_cpu_en
        struct: lc_tx
        package: lc_ctrl_pkg
        type: uni
        act: req
        width: 1
        default: lc_ctrl_pkg::Off
        inst_name: lc_ctrl
        end_idx: -1
        top_type: broadcast
        top_signame: lc_ctrl_lc_cpu_en
        index: -1
      }
      {
        name: lc_keymgr_en
        struct: lc_tx
        package: lc_ctrl_pkg
        type: uni
        act: req
        width: 1
        default: lc_ctrl_pkg::Off
        inst_name: lc_ctrl
        end_idx: -1
        top_type: broadcast
        top_signame: lc_ctrl_lc_keymgr_en
        index: -1
      }
      {
        name: lc_escalate_en
        struct: lc_tx
        package: lc_ctrl_pkg
        type: uni
        act: req
        width: 1
        default: lc_ctrl_pkg::Off
        inst_name: lc_ctrl
        end_idx: -1
        top_type: broadcast
        top_signame: lc_ctrl_lc_escalate_en
        index: -1
      }
      {
        name: lc_clk_byp_req
        struct: lc_tx
        package: lc_ctrl_pkg
        type: uni
        act: req
        width: 1
        default: lc_ctrl_pkg::Off
        inst_name: lc_ctrl
        end_idx: -1
        top_type: broadcast
        top_signame: lc_ctrl_lc_clk_byp_req
        index: -1
      }
      {
        name: lc_clk_byp_ack
        struct: lc_tx
        package: lc_ctrl_pkg
        type: uni
        act: rcv
        width: 1
        default: lc_ctrl_pkg::Off
        inst_name: lc_ctrl
        end_idx: -1
        top_type: broadcast
        top_signame: lc_ctrl_lc_clk_byp_ack
        index: -1
      }
      {
        name: lc_flash_rma_req
        struct: lc_tx
        package: lc_ctrl_pkg
        type: uni
        act: req
        width: 1
        default: lc_ctrl_pkg::Off
        inst_name: lc_ctrl
        end_idx: -1
        top_type: broadcast
        top_signame: lc_ctrl_lc_flash_rma_req
        index: -1
      }
      {
        name: lc_flash_rma_ack
        struct: lc_tx
        package: lc_ctrl_pkg
        type: uni
        act: rcv
        width: 2
        default: lc_ctrl_pkg::On
        inst_name: lc_ctrl
        end_idx: 1
        top_type: partial-one-to-N
        top_signame: lc_ctrl_lc_flash_rma_ack
        index: -1
      }
      {
        name: lc_flash_rma_seed
        struct: lc_flash_rma_seed
        package: lc_ctrl_pkg
        type: uni
        act: req
        width: 1
        default: "'0"
        inst_name: lc_ctrl
        top_signame: flash_ctrl_rma_seed
        index: -1
      }
      {
        name: lc_check_byp_en
        struct: lc_tx
        package: lc_ctrl_pkg
        type: uni
        act: req
        width: 1
        default: lc_ctrl_pkg::Off
        inst_name: lc_ctrl
        end_idx: -1
        top_type: broadcast
        top_signame: lc_ctrl_lc_check_byp_en
        index: -1
      }
      {
        name: lc_creator_seed_sw_rw_en
        struct: lc_tx
        package: lc_ctrl_pkg
        type: uni
        act: req
        width: 1
        default: lc_ctrl_pkg::Off
        inst_name: lc_ctrl
        end_idx: -1
        top_type: broadcast
        top_signame: lc_ctrl_lc_creator_seed_sw_rw_en
        index: -1
      }
      {
        name: lc_owner_seed_sw_rw_en
        struct: lc_tx
        package: lc_ctrl_pkg
        type: uni
        act: req
        width: 1
        default: lc_ctrl_pkg::Off
        inst_name: lc_ctrl
        end_idx: -1
        top_type: broadcast
        top_signame: lc_ctrl_lc_owner_seed_sw_rw_en
        index: -1
      }
      {
        name: lc_iso_part_sw_rd_en
        struct: lc_tx
        package: lc_ctrl_pkg
        type: uni
        act: req
        width: 1
        default: lc_ctrl_pkg::Off
        inst_name: lc_ctrl
        end_idx: -1
        top_type: broadcast
        top_signame: lc_ctrl_lc_iso_part_sw_rd_en
        index: -1
      }
      {
        name: lc_iso_part_sw_wr_en
        struct: lc_tx
        package: lc_ctrl_pkg
        type: uni
        act: req
        width: 1
        default: lc_ctrl_pkg::Off
        inst_name: lc_ctrl
        end_idx: -1
        top_type: broadcast
        top_signame: lc_ctrl_lc_iso_part_sw_wr_en
        index: -1
      }
      {
        name: lc_seed_hw_rd_en
        struct: lc_tx
        package: lc_ctrl_pkg
        type: uni
        act: req
        width: 1
        default: lc_ctrl_pkg::Off
        inst_name: lc_ctrl
        end_idx: -1
        top_type: broadcast
        top_signame: lc_ctrl_lc_seed_hw_rd_en
        index: -1
      }
      {
        name: lc_keymgr_div
        struct: lc_keymgr_div
        package: lc_ctrl_pkg
        type: uni
        act: req
        width: 1
        default: "'0"
        inst_name: lc_ctrl
        end_idx: -1
        top_type: broadcast
        top_signame: lc_ctrl_lc_keymgr_div
        index: -1
      }
      {
        name: otp_device_id
        struct: otp_device_id
        package: otp_ctrl_pkg
        type: uni
        act: rcv
        width: 1
        default: "'0"
        inst_name: lc_ctrl
        top_signame: lc_ctrl_otp_device_id
        index: -1
      }
      {
        name: otp_manuf_state
        struct: otp_manuf_state
        package: otp_ctrl_pkg
        type: uni
        act: rcv
        width: 1
        default: "'0"
        inst_name: lc_ctrl
        top_signame: lc_ctrl_otp_manuf_state
        index: -1
      }
      {
        name: hw_rev
        struct: lc_hw_rev
        package: lc_ctrl_pkg
        type: uni
        act: req
        width: 1
        default: "'0"
        inst_name: lc_ctrl
        index: -1
      }
      {
        name: strap_en_override
        desc:
          '''
          This signal transitions from 0 -> 1 by the lc_ctrl manager after volatile RAW_UNLOCK in order to re-sample the HW straps.
          The signal stays at 1 until reset.
          Note that this is only used in test chips when SecVolatileRawUnlockEn = 1.
          Otherwise this signal is tied off to 0.
          '''
        struct: logic
        type: uni
        act: req
        width: 1
        default: 1'b0
        inst_name: lc_ctrl
        package: ""
        end_idx: -1
        top_type: broadcast
        top_signame: lc_ctrl_strap_en_override
        index: -1
      }
      {
        name: tl
        struct: tl
        package: tlul_pkg
        type: req_rsp
        act: rsp
        width: 1
        inst_name: lc_ctrl
        default: ""
        end_idx: -1
        top_signame: lc_ctrl_tl
        index: -1
      }
      {
        name: crashdump
        struct: alert_crashdump
        package: alert_pkg
        type: uni
        act: req
        width: 1
        inst_name: alert_handler
        default: ""
        end_idx: -1
        top_type: broadcast
        top_signame: alert_handler_crashdump
        index: -1
      }
      {
        name: edn
        struct: edn
        package: edn_pkg
        type: req_rsp
        act: req
        width: 1
        inst_name: alert_handler
        default: ""
        top_signame: edn0_edn
        index: 4
      }
      {
        name: esc_rx
        struct: esc_rx
        package: prim_esc_pkg
        type: uni
        act: rcv
        width: 4
        inst_name: alert_handler
        default: ""
        end_idx: -1
        top_type: one-to-N
        top_signame: alert_handler_esc_rx
        index: -1
      }
      {
        name: esc_tx
        struct: esc_tx
        package: prim_esc_pkg
        type: uni
        act: req
        width: 4
        inst_name: alert_handler
        default: ""
        end_idx: -1
        top_type: one-to-N
        top_signame: alert_handler_esc_tx
        index: -1
      }
      {
        name: tl
        struct: tl
        package: tlul_pkg
        type: req_rsp
        act: rsp
        width: 1
        inst_name: alert_handler
        default: ""
        end_idx: -1
        top_signame: alert_handler_tl
        index: -1
      }
      {
        name: passthrough
        struct: passthrough
        package: spi_device_pkg
        type: req_rsp
        act: rsp
        width: 1
        inst_name: spi_host0
        default: ""
        top_signame: spi_device_passthrough
        index: -1
      }
      {
        name: tl
        struct: tl
        package: tlul_pkg
        type: req_rsp
        act: rsp
        width: 1
        inst_name: spi_host0
        default: ""
        end_idx: -1
        top_signame: spi_host0_tl
        index: -1
      }
      {
        name: pwr_ast
        struct: pwr_ast
        package: pwrmgr_pkg
        type: req_rsp
        act: req
        width: 1
        inst_name: pwrmgr_aon
        default: ""
        external: true
        top_signame: pwrmgr_ast
        conn_type: false
        index: -1
      }
      {
        name: pwr_rst
        struct: pwr_rst
        package: pwrmgr_pkg
        type: req_rsp
        act: req
        width: 1
        inst_name: pwrmgr_aon
        default: ""
        end_idx: -1
        top_signame: pwrmgr_aon_pwr_rst
        index: -1
      }
      {
        name: pwr_clk
        struct: pwr_clk
        package: pwrmgr_pkg
        type: req_rsp
        act: req
        width: 1
        inst_name: pwrmgr_aon
        default: ""
        end_idx: -1
        top_signame: pwrmgr_aon_pwr_clk
        index: -1
      }
      {
        name: pwr_otp
        struct: pwr_otp
        package: pwrmgr_pkg
        type: req_rsp
        act: req
        width: 1
        inst_name: pwrmgr_aon
        default: ""
        end_idx: -1
        top_signame: pwrmgr_aon_pwr_otp
        index: -1
      }
      {
        name: pwr_lc
        struct: pwr_lc
        package: pwrmgr_pkg
        type: req_rsp
        act: req
        width: 1
        inst_name: pwrmgr_aon
        default: ""
        end_idx: -1
        top_signame: pwrmgr_aon_pwr_lc
        index: -1
      }
      {
        name: pwr_flash
        struct: pwr_flash
        package: pwrmgr_pkg
        type: uni
        act: rcv
        width: 1
        inst_name: pwrmgr_aon
        default: ""
        end_idx: -1
        top_type: broadcast
        top_signame: pwrmgr_aon_pwr_flash
        index: -1
      }
      {
        name: esc_rst_tx
        struct: esc_tx
        package: prim_esc_pkg
        type: uni
        act: rcv
        width: 1
        inst_name: pwrmgr_aon
        default: ""
        top_signame: alert_handler_esc_tx
        index: 3
      }
      {
        name: esc_rst_rx
        struct: esc_rx
        package: prim_esc_pkg
        type: uni
        act: req
        width: 1
        inst_name: pwrmgr_aon
        default: ""
        top_signame: alert_handler_esc_rx
        index: 3
      }
      {
        name: pwr_cpu
        struct: pwr_cpu
        package: pwrmgr_pkg
        type: uni
        act: rcv
        width: 1
        inst_name: pwrmgr_aon
        default: ""
        top_signame: rv_core_ibex_pwrmgr
        index: -1
      }
      {
        name: wakeups
        struct: logic
        type: uni
        act: rcv
        width: 3
        inst_name: pwrmgr_aon
        default: ""
        package: ""
        end_idx: -1
        top_type: one-to-N
        top_signame: pwrmgr_aon_wakeups
        index: -1
      }
      {
        name: rstreqs
        struct: logic
        type: uni
        act: rcv
        width: 1
        inst_name: pwrmgr_aon
        default: ""
        package: ""
        end_idx: -1
        top_type: broadcast
        top_signame: pwrmgr_aon_rstreqs
        index: -1
      }
      {
        name: ndmreset_req
        struct: logic
        type: uni
        act: rcv
        width: 1
        inst_name: pwrmgr_aon
        default: ""
        package: ""
        top_signame: rv_dm_ndmreset_req
        index: -1
      }
      {
        name: strap
        struct: logic
        type: uni
        act: req
        width: 1
        inst_name: pwrmgr_aon
        default: ""
        package: ""
        end_idx: -1
        top_type: broadcast
        top_signame: pwrmgr_aon_strap
        index: -1
      }
      {
        name: low_power
        struct: logic
        type: uni
        act: req
        width: 1
        inst_name: pwrmgr_aon
        default: ""
        package: ""
        end_idx: -1
        top_type: broadcast
        top_signame: pwrmgr_aon_low_power
        index: -1
      }
      {
        name: rom_ctrl
        struct: pwrmgr_data
        package: rom_ctrl_pkg
        type: uni
        act: rcv
        width: 1
        inst_name: pwrmgr_aon
        default: ""
        top_signame: rom_ctrl_pwrmgr_data
        index: -1
      }
      {
        name: fetch_en
        struct: lc_tx
        package: lc_ctrl_pkg
        type: uni
        act: req
        width: 1
        inst_name: pwrmgr_aon
        default: ""
        end_idx: -1
        top_type: broadcast
        top_signame: pwrmgr_aon_fetch_en
        index: -1
      }
      {
        name: lc_dft_en
        struct: lc_tx
        package: lc_ctrl_pkg
        type: uni
        act: rcv
        width: 1
        inst_name: pwrmgr_aon
        default: ""
        top_signame: lc_ctrl_lc_dft_en
        index: -1
      }
      {
        name: lc_hw_debug_en
        struct: lc_tx
        package: lc_ctrl_pkg
        type: uni
        act: rcv
        width: 1
        inst_name: pwrmgr_aon
        default: ""
        top_signame: lc_ctrl_lc_hw_debug_en
        index: -1
      }
      {
        name: sw_rst_req
        struct: mubi4
        package: prim_mubi_pkg
        type: uni
        act: rcv
        width: 1
        inst_name: pwrmgr_aon
        default: ""
        top_signame: rstmgr_aon_sw_rst_req
        index: -1
      }
      {
        name: tl
        struct: tl
        package: tlul_pkg
        type: req_rsp
        act: rsp
        width: 1
        inst_name: pwrmgr_aon
        default: ""
        end_idx: -1
        top_signame: pwrmgr_aon_tl
        index: -1
      }
      {
        name: por_n
        desc:
          '''
          Root power on reset signals from ast.
          There is one root reset signal for each core power domain.
          '''
        struct: logic
        type: uni
        act: rcv
        width: 2
        inst_name: rstmgr_aon
        default: ""
        package: ""
        external: true
        top_signame: por_n
        conn_type: false
        index: -1
      }
      {
        name: pwr
        desc:
          '''
          Reset request signals from power manager.
          Power manager can request for specific domains of the lc/sys reset tree to assert.
          '''
        struct: pwr_rst
        type: req_rsp
        act: rsp
        width: 1
        inst_name: rstmgr_aon
        default: ""
        package: pwrmgr_pkg
        top_signame: pwrmgr_aon_pwr_rst
        index: -1
      }
      {
        name: resets
        desc: Leaf resets fed to the system.
        struct: rstmgr_out
        package: rstmgr_pkg
        type: uni
        act: req
        width: 1
        inst_name: rstmgr_aon
        default: ""
        top_signame: rstmgr_aon_resets
        index: -1
      }
      {
        name: rst_en
        desc: Low-power-group outputs used by alert handler.
        struct: rstmgr_rst_en
        package: rstmgr_pkg
        type: uni
        act: req
        width: 1
        inst_name: rstmgr_aon
        default: ""
        top_signame: rstmgr_aon_rst_en
        index: -1
      }
      {
        name: alert_dump
        desc: Alert handler crash dump information.
        struct: alert_crashdump
        package: alert_pkg
        type: uni
        act: rcv
        width: 1
        inst_name: rstmgr_aon
        default: ""
        top_signame: alert_handler_crashdump
        index: -1
      }
      {
        name: cpu_dump
        desc: Main processing element crash dump information.
        struct: cpu_crash_dump
        package: rv_core_ibex_pkg
        type: uni
        act: rcv
        width: 1
        inst_name: rstmgr_aon
        default: ""
        top_signame: rv_core_ibex_crash_dump
        index: -1
      }
      {
        name: sw_rst_req
        desc: Software requested system reset to pwrmgr.
        struct: mubi4
        package: prim_mubi_pkg
        type: uni
        act: req
        width: 1
        inst_name: rstmgr_aon
        default: ""
        end_idx: -1
        top_type: broadcast
        top_signame: rstmgr_aon_sw_rst_req
        index: -1
      }
      {
        name: tl
        struct: tl
        package: tlul_pkg
        type: req_rsp
        act: rsp
        width: 1
        inst_name: rstmgr_aon
        default: ""
        end_idx: -1
        top_signame: rstmgr_aon_tl
        index: -1
      }
      {
        name: clocks
        struct: clkmgr_out
        package: clkmgr_pkg
        type: uni
        act: req
        width: 1
        inst_name: clkmgr_aon
        default: ""
        top_signame: clkmgr_aon_clocks
        index: -1
      }
      {
        name: cg_en
        struct: clkmgr_cg_en
        package: clkmgr_pkg
        type: uni
        act: req
        width: 1
        inst_name: clkmgr_aon
        default: ""
        top_signame: clkmgr_aon_cg_en
        index: -1
      }
      {
        name: lc_hw_debug_en
        struct: lc_tx
        package: lc_ctrl_pkg
        type: uni
        act: rcv
        width: 1
        inst_name: clkmgr_aon
        default: ""
        top_signame: lc_ctrl_lc_hw_debug_en
        index: -1
      }
      {
        name: io_clk_byp_req
        struct: mubi4
        package: prim_mubi_pkg
        type: uni
        act: req
        width: 1
        inst_name: clkmgr_aon
        default: ""
        external: true
        top_signame: io_clk_byp_req
        conn_type: false
        index: -1
      }
      {
        name: io_clk_byp_ack
        struct: mubi4
        package: prim_mubi_pkg
        type: uni
        act: rcv
        width: 1
        inst_name: clkmgr_aon
        default: ""
        external: true
        top_signame: io_clk_byp_ack
        conn_type: false
        index: -1
      }
      {
        name: all_clk_byp_req
        struct: mubi4
        package: prim_mubi_pkg
        type: uni
        act: req
        width: 1
        inst_name: clkmgr_aon
        default: ""
        external: true
        top_signame: all_clk_byp_req
        conn_type: false
        index: -1
      }
      {
        name: all_clk_byp_ack
        struct: mubi4
        package: prim_mubi_pkg
        type: uni
        act: rcv
        width: 1
        inst_name: clkmgr_aon
        default: ""
        external: true
        top_signame: all_clk_byp_ack
        conn_type: false
        index: -1
      }
      {
        name: hi_speed_sel
        struct: mubi4
        package: prim_mubi_pkg
        type: uni
        act: req
        width: 1
        inst_name: clkmgr_aon
        default: ""
        external: true
        top_signame: hi_speed_sel
        conn_type: false
        index: -1
      }
      {
        name: div_step_down_req
        struct: mubi4
        package: prim_mubi_pkg
        type: uni
        act: rcv
        width: 1
        inst_name: clkmgr_aon
        default: ""
        external: true
        top_signame: div_step_down_req
        conn_type: false
        index: -1
      }
      {
        name: lc_clk_byp_req
        struct: lc_tx
        package: lc_ctrl_pkg
        type: uni
        act: rcv
        width: 1
        inst_name: clkmgr_aon
        default: ""
        top_signame: lc_ctrl_lc_clk_byp_req
        index: -1
      }
      {
        name: lc_clk_byp_ack
        struct: lc_tx
        package: lc_ctrl_pkg
        type: uni
        act: req
        width: 1
        inst_name: clkmgr_aon
        default: ""
        top_signame: lc_ctrl_lc_clk_byp_ack
        index: -1
      }
      {
        name: jitter_en
        struct: mubi4
        package: prim_mubi_pkg
        type: uni
        act: req
        width: 1
        inst_name: clkmgr_aon
        default: ""
        external: true
        top_signame: clk_main_jitter_en
        conn_type: false
        index: -1
      }
      {
        name: pwr
        struct: pwr_clk
        type: req_rsp
        act: rsp
        width: 1
        inst_name: clkmgr_aon
        default: ""
        package: pwrmgr_pkg
        top_signame: pwrmgr_aon_pwr_clk
        index: -1
      }
      {
        name: idle
        struct: mubi4
        package: prim_mubi_pkg
        type: uni
        act: rcv
        width: 1
        inst_name: clkmgr_aon
        default: ""
        end_idx: -1
        top_type: broadcast
        top_signame: clkmgr_aon_idle
        index: -1
      }
      {
        name: calib_rdy
        desc: Indicates clocks are calibrated and frequencies accurate
        struct: mubi4
        package: prim_mubi_pkg
        type: uni
        act: rcv
        width: 1
        default: prim_mubi_pkg::MuBi4True
        inst_name: clkmgr_aon
        external: true
        top_signame: calib_rdy
        conn_type: false
        index: -1
      }
      {
        name: tl
        struct: tl
        package: tlul_pkg
        type: req_rsp
        act: rsp
        width: 1
        inst_name: clkmgr_aon
        default: ""
        end_idx: -1
        top_signame: clkmgr_aon_tl
        index: -1
      }
      {
        name: lc_hw_debug_en
        desc: Debug enable qualifier coming from life cycle controller, used for HW strap qualification.
        struct: lc_tx
        package: lc_ctrl_pkg
        type: uni
        act: rcv
        width: 1
        default: lc_ctrl_pkg::Off
        inst_name: pinmux_aon
        top_signame: lc_ctrl_lc_hw_debug_en
        index: -1
      }
      {
        name: lc_dft_en
        desc: Test enable qualifier coming from life cycle controller, used for HW strap qualification.
        struct: lc_tx
        package: lc_ctrl_pkg
        type: uni
        act: rcv
        width: 1
        default: lc_ctrl_pkg::Off
        inst_name: pinmux_aon
        top_signame: lc_ctrl_lc_dft_en
        index: -1
      }
      {
        name: lc_escalate_en
        desc:
          '''
          Escalation enable signal coming from life cycle controller, used for invalidating
          the latched lc_hw_debug_en state inside the strap sampling logic.
          '''
        struct: lc_tx
        package: lc_ctrl_pkg
        type: uni
        act: rcv
        width: 1
        default: lc_ctrl_pkg::Off
        inst_name: pinmux_aon
        top_signame: lc_ctrl_lc_escalate_en
        index: -1
      }
      {
        name: lc_check_byp_en
        desc:
          '''
          Check bypass enable signal coming from life cycle controller, used for invalidating
          the latched lc_hw_debug_en state inside the strap sampling logic. This signal is asserted
          whenever the life cycle controller performs a life cycle transition. Its main use is
          to skip any background checks inside the life cycle partition of the OTP controller while
          a life cycle transition is in progress.
          '''
        struct: lc_tx
        package: lc_ctrl_pkg
        type: uni
        act: rcv
        width: 1
        default: lc_ctrl_pkg::Off
        inst_name: pinmux_aon
        top_signame: lc_ctrl_lc_check_byp_en
        index: -1
      }
      {
        name: pinmux_hw_debug_en
        desc:
          '''
          This is the latched version of lc_hw_debug_en_i. We use it exclusively to gate the JTAG
          signals and TAP side of the RV_DM so that RV_DM can remain live during an NDM reset cycle.
          '''
        struct: lc_tx
        package: lc_ctrl_pkg
        type: uni
        act: req
        width: 1
        default: lc_ctrl_pkg::Off
        inst_name: pinmux_aon
        end_idx: -1
        top_type: broadcast
        top_signame: pinmux_aon_pinmux_hw_debug_en
        index: -1
      }
      {
        name: lc_jtag
        desc: Qualified JTAG signals for life cycle controller TAP.
        struct: jtag
        package: jtag_pkg
        type: req_rsp
        act: req
        width: 1
        inst_name: pinmux_aon
        default: ""
        end_idx: -1
        top_signame: pinmux_aon_lc_jtag
        index: -1
      }
      {
        name: rv_jtag
        desc: Qualified JTAG signals for RISC-V processor TAP.
        struct: jtag
        package: jtag_pkg
        type: req_rsp
        act: req
        width: 1
        inst_name: pinmux_aon
        default: ""
        end_idx: -1
        top_signame: pinmux_aon_rv_jtag
        index: -1
      }
      {
        name: dft_jtag
        desc: Qualified JTAG signals for DFT TAP.
        struct: jtag
        package: jtag_pkg
        type: req_rsp
        act: req
        width: 1
        inst_name: pinmux_aon
        default: ""
        top_signame: pinmux_aon_dft_jtag
        index: -1
      }
      {
        name: dft_strap_test
        desc: Sampled DFT strap values, going to the DFT TAP.
        struct: dft_strap_test_req
        package: pinmux_pkg
        type: uni
        act: req
        width: 1
        default: "'0"
        inst_name: pinmux_aon
        external: true
        top_signame: dft_strap_test
        conn_type: false
        index: -1
      }
      {
        name: dft_hold_tap_sel
        desc: TAP selection hold indication, asserted by the DFT TAP during boundary scan.
        struct: logic
        type: uni
        act: rcv
        width: 1
        default: "'0"
        inst_name: pinmux_aon
        package: ""
        external: true
        top_signame: dft_hold_tap_sel
        conn_type: false
        index: -1
      }
      {
        name: sleep_en
        desc: Level signal that is asserted when the power manager enters sleep.
        struct: logic
        type: uni
        act: rcv
        width: 1
        default: 1'b0
        inst_name: pinmux_aon
        package: ""
        top_signame: pwrmgr_aon_low_power
        index: -1
      }
      {
        name: strap_en
        desc: This signal is pulsed high by the power manager after reset in order to sample the HW straps.
        struct: logic
        type: uni
        act: rcv
        width: 1
        default: 1'b0
        inst_name: pinmux_aon
        package: ""
        top_signame: pwrmgr_aon_strap
        index: -1
      }
      {
        name: strap_en_override
        desc:
          '''
          This signal transitions from 0 -> 1 by the lc_ctrl manager after volatile RAW_UNLOCK in order to re-sample the HW straps.
          The signal must stay at 1 until reset.
          Note that this is only used in test chips when SecVolatileRawUnlockEn = 1.
          Otherwise this signal is unused.
          '''
        struct: logic
        type: uni
        act: rcv
        width: 1
        default: 1'b0
        inst_name: pinmux_aon
        package: ""
        top_signame: lc_ctrl_strap_en_override
        index: -1
      }
      {
        name: pin_wkup_req
        desc: Wakeup request from wakeup detectors, to the power manager, running on the AON clock.
        struct: logic
        type: uni
        act: req
        width: 1
        default: 1'b0
        inst_name: pinmux_aon
        package: ""
        top_signame: pwrmgr_aon_wakeups
        index: 0
      }
      {
        name: usbdev_dppullup_en
        desc: Pullup enable signal coming from the USB IP.
        struct: logic
        type: uni
        act: rcv
        width: 1
        inst_name: pinmux_aon
        index: -1
      }
      {
        name: usbdev_dnpullup_en
        desc: Pullup enable signal coming from the USB IP.
        struct: logic
        type: uni
        act: rcv
        width: 1
        inst_name: pinmux_aon
        index: -1
      }
      {
        name: usb_dppullup_en
        desc: " Pullup enable signal going to USB PHY, needs to be maintained in low-power mode."
        struct: logic
        type: uni
        act: req
        width: 1
        default: 1'b0
        inst_name: pinmux_aon
        package: ""
        external: true
        top_signame: usb_dp_pullup_en
        conn_type: false
        index: -1
      }
      {
        name: usb_dnpullup_en
        desc: Pullup enable signal going to USB PHY, needs to be maintained in low-power mode.
        struct: logic
        type: uni
        act: req
        width: 1
        default: 1'b0
        inst_name: pinmux_aon
        package: ""
        external: true
        top_signame: usb_dn_pullup_en
        conn_type: false
        index: -1
      }
      {
        name: usb_wkup_req
        desc: Wakeup request from USB wakeup detector, going to the power manager, running on the AON clock.
        struct: logic
        type: uni
        act: req
        width: 1
        default: 1'b0
        inst_name: pinmux_aon
        package: ""
        top_signame: pwrmgr_aon_wakeups
        index: 1
      }
      {
        name: usbdev_suspend_req
        desc: Indicates whether USB is in suspended state, coming from the USB device.
        struct: logic
        type: uni
        act: rcv
        width: 1
        inst_name: pinmux_aon
        index: -1
      }
      {
        name: usbdev_wake_ack
        desc: Acknowledges the USB wakeup request, coming from the USB device.
        struct: logic
        type: uni
        act: rcv
        width: 1
        inst_name: pinmux_aon
        index: -1
      }
      {
        name: usbdev_bus_not_idle
        desc: Event signal that indicates that the USB was not idle while monitoring.
        struct: logic
        type: uni
        act: req
        width: 1
        default: 1'b0
        inst_name: pinmux_aon
        index: -1
      }
      {
        name: usbdev_bus_reset
        desc: Event signal that indicates that the USB issued a Bus Reset while monitoring.
        struct: logic
        type: uni
        act: req
        width: 1
        default: 1'b0
        inst_name: pinmux_aon
        index: -1
      }
      {
        name: usbdev_sense_lost
        desc: Event signal that indicates that USB SENSE signal was lost while monitoring.
        struct: logic
        type: uni
        act: req
        width: 1
        default: 1'b0
        inst_name: pinmux_aon
        index: -1
      }
      {
        name: usbdev_wake_detect_active
        desc: State debug information.
        struct: logic
        type: uni
        act: req
        width: 1
        default: 1'b0
        inst_name: pinmux_aon
        index: -1
      }
      {
        name: tl
        struct: tl
        package: tlul_pkg
        type: req_rsp
        act: rsp
        width: 1
        inst_name: pinmux_aon
        default: ""
        end_idx: -1
        top_signame: pinmux_aon_tl
        index: -1
      }
      {
        name: nmi_wdog_timer_bark
        struct: logic
        type: uni
        act: req
        width: 1
        default: 1'b0
        inst_name: aon_timer_aon
        package: ""
        end_idx: -1
        top_type: broadcast
        top_signame: aon_timer_aon_nmi_wdog_timer_bark
        index: -1
      }
      {
        name: wkup_req
        struct: logic
        type: uni
        act: req
        width: 1
        default: 1'b0
        inst_name: aon_timer_aon
        package: ""
        top_signame: pwrmgr_aon_wakeups
        index: 2
      }
      {
        name: aon_timer_rst_req
        struct: logic
        type: uni
        act: req
        width: 1
        default: 1'b0
        inst_name: aon_timer_aon
        package: ""
        top_signame: pwrmgr_aon_rstreqs
        index: -1
      }
      {
        name: lc_escalate_en
        struct: lc_tx
        package: lc_ctrl_pkg
        type: uni
        act: rcv
        width: 1
        default: lc_ctrl_pkg::Off
        inst_name: aon_timer_aon
        top_signame: lc_ctrl_lc_escalate_en
        index: -1
      }
      {
        name: sleep_mode
        struct: logic
        type: uni
        act: rcv
        width: 1
        inst_name: aon_timer_aon
        default: ""
        package: ""
        top_signame: pwrmgr_aon_low_power
        index: -1
      }
      {
        name: tl
        struct: tl
        package: tlul_pkg
        type: req_rsp
        act: rsp
        width: 1
        inst_name: aon_timer_aon
        default: ""
        end_idx: -1
        top_signame: aon_timer_aon_tl
        index: -1
      }
      {
        name: tl
        struct: tl
        package: tlul_pkg
        type: req_rsp
        act: rsp
        width: 1
        inst_name: ast
        index: -1
      }
      {
        name: sram_otp_key
        struct: sram_otp_key
        package: otp_ctrl_pkg
        type: req_rsp
        act: req
        width: 1
        inst_name: sram_ctrl_ret_aon
        default: ""
        top_signame: otp_ctrl_sram_otp_key
        index: 1
      }
      {
        name: cfg
        struct: ram_1p_cfg
        package: prim_ram_1p_pkg
        type: uni
        act: rcv
        width: 1
        default: "'0"
        inst_name: sram_ctrl_ret_aon
        top_signame: ast_ram_1p_cfg
        index: -1
      }
      {
        name: lc_escalate_en
        struct: lc_tx
        package: lc_ctrl_pkg
        type: uni
        act: rcv
        width: 1
        default: lc_ctrl_pkg::Off
        inst_name: sram_ctrl_ret_aon
        top_signame: lc_ctrl_lc_escalate_en
        index: -1
      }
      {
        name: lc_hw_debug_en
        struct: lc_tx
        package: lc_ctrl_pkg
        type: uni
        act: rcv
        width: 1
        default: lc_ctrl_pkg::Off
        inst_name: sram_ctrl_ret_aon
        index: -1
      }
      {
        name: otp_en_sram_ifetch
        struct: mubi8
        package: prim_mubi_pkg
        type: uni
        act: rcv
        width: 1
        default: prim_mubi_pkg::MuBi8False
        inst_name: sram_ctrl_ret_aon
        index: -1
      }
      {
        name: regs_tl
        struct: tl
        package: tlul_pkg
        type: req_rsp
        act: rsp
        width: 1
        inst_name: sram_ctrl_ret_aon
        default: ""
        end_idx: -1
        top_signame: sram_ctrl_ret_aon_regs_tl
        index: -1
      }
      {
        name: ram_tl
        struct: tl
        package: tlul_pkg
        type: req_rsp
        act: rsp
        width: 1
        inst_name: sram_ctrl_ret_aon
        default: ""
        end_idx: -1
        top_signame: sram_ctrl_ret_aon_ram_tl
        index: -1
      }
      {
        name: otp
        struct: flash_otp_key
        package: otp_ctrl_pkg
        type: req_rsp
        act: req
        width: 1
        inst_name: flash_ctrl
        default: ""
        end_idx: -1
        top_signame: flash_ctrl_otp
        index: -1
      }
      {
        name: lc_nvm_debug_en
        struct: lc_tx
        package: lc_ctrl_pkg
        type: uni
        act: rcv
        width: 1
        inst_name: flash_ctrl
        default: ""
        top_signame: lc_ctrl_lc_nvm_debug_en
        index: -1
      }
      {
        name: flash_bist_enable
        struct: mubi4
        package: prim_mubi_pkg
        type: uni
        act: rcv
        width: 1
        inst_name: flash_ctrl
        default: ""
        external: true
        top_signame: flash_bist_enable
        conn_type: false
        index: -1
      }
      {
        name: flash_power_down_h
        struct: logic
        type: uni
        act: rcv
        width: 1
        inst_name: flash_ctrl
        default: ""
        package: ""
        external: true
        top_signame: flash_power_down_h
        conn_type: false
        index: -1
      }
      {
        name: flash_power_ready_h
        struct: logic
        type: uni
        act: rcv
        width: 1
        inst_name: flash_ctrl
        default: ""
        package: ""
        external: true
        top_signame: flash_power_ready_h
        conn_type: false
        index: -1
      }
      {
        name: flash_test_mode_a
        struct: ""
        type: io
        act: none
        width: 2
        inst_name: flash_ctrl
        default: ""
        package: ""
        external: true
        top_signame: flash_test_mode_a
        conn_type: false
        index: -1
      }
      {
        name: flash_test_voltage_h
        struct: ""
        type: io
        act: none
        width: 1
        inst_name: flash_ctrl
        default: ""
        package: ""
        external: true
        top_signame: flash_test_voltage_h
        conn_type: false
        index: -1
      }
      {
        name: lc_creator_seed_sw_rw_en
        struct: lc_tx
        package: lc_ctrl_pkg
        type: uni
        act: rcv
        width: 1
        inst_name: flash_ctrl
        default: ""
        top_signame: lc_ctrl_lc_creator_seed_sw_rw_en
        index: -1
      }
      {
        name: lc_owner_seed_sw_rw_en
        struct: lc_tx
        package: lc_ctrl_pkg
        type: uni
        act: rcv
        width: 1
        inst_name: flash_ctrl
        default: ""
        top_signame: lc_ctrl_lc_owner_seed_sw_rw_en
        index: -1
      }
      {
        name: lc_iso_part_sw_rd_en
        struct: lc_tx
        package: lc_ctrl_pkg
        type: uni
        act: rcv
        width: 1
        inst_name: flash_ctrl
        default: ""
        top_signame: lc_ctrl_lc_iso_part_sw_rd_en
        index: -1
      }
      {
        name: lc_iso_part_sw_wr_en
        struct: lc_tx
        package: lc_ctrl_pkg
        type: uni
        act: rcv
        width: 1
        inst_name: flash_ctrl
        default: ""
        top_signame: lc_ctrl_lc_iso_part_sw_wr_en
        index: -1
      }
      {
        name: lc_seed_hw_rd_en
        struct: lc_tx
        package: lc_ctrl_pkg
        type: uni
        act: rcv
        width: 1
        inst_name: flash_ctrl
        default: ""
        top_signame: lc_ctrl_lc_seed_hw_rd_en
        index: -1
      }
      {
        name: lc_escalate_en
        struct: lc_tx
        package: lc_ctrl_pkg
        type: uni
        act: rcv
        width: 1
        inst_name: flash_ctrl
        default: ""
        top_signame: lc_ctrl_lc_escalate_en
        index: -1
      }
      {
        name: rma_req
        struct: lc_tx
        package: lc_ctrl_pkg
        type: uni
        act: rcv
        width: 1
        inst_name: flash_ctrl
        default: ""
        top_signame: lc_ctrl_lc_flash_rma_req
        index: -1
      }
      {
        name: rma_ack
        struct: lc_tx
        package: lc_ctrl_pkg
        type: uni
        act: req
        width: 1
        inst_name: flash_ctrl
        default: ""
        top_signame: lc_ctrl_lc_flash_rma_ack
        index: 0
      }
      {
        name: rma_seed
        struct: lc_flash_rma_seed
        package: lc_ctrl_pkg
        type: uni
        act: rcv
        width: 1
        inst_name: flash_ctrl
        default: ""
        end_idx: -1
        top_type: broadcast
        top_signame: flash_ctrl_rma_seed
        index: -1
      }
      {
        name: pwrmgr
        struct: pwr_flash
        package: pwrmgr_pkg
        type: uni
        act: req
        width: 1
        inst_name: flash_ctrl
        default: ""
        top_signame: pwrmgr_aon_pwr_flash
        index: -1
      }
      {
        name: keymgr
        struct: keymgr_flash
        package: flash_ctrl_pkg
        type: uni
        act: req
        width: 1
        inst_name: flash_ctrl
        default: ""
        end_idx: -1
        top_type: broadcast
        top_signame: flash_ctrl_keymgr
        index: -1
      }
      {
        name: obs_ctrl
        struct: ast_obs_ctrl
        package: ast_pkg
        type: uni
        act: rcv
        width: 1
        inst_name: flash_ctrl
        default: ""
        top_signame: ast_obs_ctrl
        index: -1
      }
      {
        name: fla_obs
        struct: logic
        type: uni
        act: req
        width: 8
        inst_name: flash_ctrl
        default: ""
        package: ""
        external: true
        top_signame: flash_obs
        conn_type: false
        index: -1
      }
      {
        name: core_tl
        struct: tl
        package: tlul_pkg
        type: req_rsp
        act: rsp
        width: 1
        inst_name: flash_ctrl
        default: ""
        end_idx: -1
        top_signame: flash_ctrl_core_tl
        index: -1
      }
      {
        name: prim_tl
        struct: tl
        package: tlul_pkg
        type: req_rsp
        act: rsp
        width: 1
        inst_name: flash_ctrl
        default: ""
        end_idx: -1
        top_signame: flash_ctrl_prim_tl
        index: -1
      }
      {
        name: mem_tl
        struct: tl
        package: tlul_pkg
        type: req_rsp
        act: rsp
        width: 1
        inst_name: flash_ctrl
        default: ""
        end_idx: -1
        top_signame: flash_ctrl_mem_tl
        index: -1
      }
      {
        name: next_dm_addr
        desc:
          '''
          32bit word address of the next debug module.
          Set to 0x0 if this is the last debug module in the chain.
          '''
        struct: next_dm_addr
        package: rv_dm_pkg
        type: uni
        act: rcv
        width: 1
        default: "'0"
        inst_name: rv_dm
        index: -1
      }
      {
        name: jtag
        desc: JTAG signals for the RISC-V TAP.
        struct: jtag
        package: jtag_pkg
        type: req_rsp
        act: rsp
        width: 1
        inst_name: rv_dm
        default: ""
        top_signame: pinmux_aon_rv_jtag
        index: -1
      }
      {
        name: lc_hw_debug_en
        desc:
          '''
          Multibit life cycle hardware debug enable signal coming from life cycle controller,
          asserted when the hardware debug mechanisms are enabled in the system.
          '''
        struct: lc_tx
        package: lc_ctrl_pkg
        type: uni
        act: rcv
        width: 1
        default: lc_ctrl_pkg::Off
        inst_name: rv_dm
        top_signame: lc_ctrl_lc_hw_debug_en
        index: -1
      }
      {
        name: lc_dft_en
        desc:
          '''
          Multibit life cycle hardware debug enable signal coming from life cycle controller,
          asserted when the DFT mechanisms are enabled in the system.
          '''
        struct: lc_tx
        package: lc_ctrl_pkg
        type: uni
        act: rcv
        width: 1
        default: lc_ctrl_pkg::Off
        inst_name: rv_dm
        top_signame: lc_ctrl_lc_dft_en
        index: -1
      }
      {
        name: pinmux_hw_debug_en
        desc:
          '''
          Multibit life cycle hardware debug enable signal coming from pinmux.
          This is a latched version of the lc_hw_debug_en signal and is only used to
          gate the JTAG / TAP side of the RV_DM. It is used to keep a debug session live
          while the rest of the system undergoes an NDM reset.
          '''
        struct: lc_tx
        package: lc_ctrl_pkg
        type: uni
        act: rcv
        width: 1
        default: lc_ctrl_pkg::Off
        inst_name: rv_dm
        top_signame: pinmux_aon_pinmux_hw_debug_en
        index: -1
      }
      {
        name: otp_dis_rv_dm_late_debug
        struct: mubi8
        package: prim_mubi_pkg
        type: uni
        act: rcv
        width: 1
        default: prim_mubi_pkg::MuBi8False
        inst_name: rv_dm
        top_signame: rv_dm_otp_dis_rv_dm_late_debug
        index: -1
      }
      {
        name: unavailable
        desc:
          '''
          This signal indicates to the debug module that the main processor is not available
          for debug (e.g. due to a low-power state).
          '''
        struct: logic
        type: uni
        act: rcv
        width: 1
        default: 1'b0
        inst_name: rv_dm
        index: -1
      }
      {
        name: ndmreset_req
        desc: Non-debug module reset request going to the system reset infrastructure.
        struct: logic
        type: uni
        act: req
        width: 1
        inst_name: rv_dm
        default: ""
        package: ""
        end_idx: -1
        top_type: broadcast
        top_signame: rv_dm_ndmreset_req
        index: -1
      }
      {
        name: dmactive
        desc:
          '''
          This signal indicates whether the debug module is active and can be used to prevent
          power down of the core and bus-attached peripherals.
          '''
        struct: logic
        type: uni
        act: req
        width: 1
        inst_name: rv_dm
        index: -1
      }
      {
        name: debug_req
        desc: This is the debug request interrupt going to the main processor.
        struct: logic [rv_dm_reg_pkg::NrHarts-1:0]
        type: uni
        act: req
        width: 1
        inst_name: rv_dm
        default: ""
        package: ""
        end_idx: -1
        top_type: broadcast
        top_signame: rv_dm_debug_req
        index: -1
      }
      {
        name: sba_tl_h
        struct: tl
        package: tlul_pkg
        type: req_rsp
        act: req
        width: 1
        inst_name: rv_dm
        default: ""
        top_signame: main_tl_rv_dm__sba
        index: -1
      }
      {
        name: regs_tl_d
        struct: tl
        package: tlul_pkg
        type: req_rsp
        act: rsp
        width: 1
        inst_name: rv_dm
        default: ""
        end_idx: -1
        top_signame: rv_dm_regs_tl_d
        index: -1
      }
      {
        name: mem_tl_d
        struct: tl
        package: tlul_pkg
        type: req_rsp
        act: rsp
        width: 1
        inst_name: rv_dm
        default: ""
        end_idx: -1
        top_signame: rv_dm_mem_tl_d
        index: -1
      }
      {
        name: irq
        struct: logic
        type: uni
        act: req
        width: 1
        inst_name: rv_plic
        default: ""
        package: ""
        end_idx: -1
        top_type: broadcast
        top_signame: rv_plic_irq
        index: -1
      }
      {
        name: irq_id
        struct: logic
        type: uni
        act: req
        width: 1
        inst_name: rv_plic
        index: -1
      }
      {
        name: msip
        struct: logic
        type: uni
        act: req
        width: 1
        inst_name: rv_plic
        default: ""
        package: ""
        end_idx: -1
        top_type: broadcast
        top_signame: rv_plic_msip
        index: -1
      }
      {
        name: tl
        struct: tl
        package: tlul_pkg
        type: req_rsp
        act: rsp
        width: 1
        inst_name: rv_plic
        default: ""
        end_idx: -1
        top_signame: rv_plic_tl
        index: -1
      }
      {
        name: edn
        struct: edn
        package: edn_pkg
        type: req_rsp
        act: req
        width: 1
        inst_name: keymgr
        default: ""
        top_signame: edn0_edn
        index: 0
      }
      {
        name: aes_key
        struct: hw_key_req
        package: keymgr_pkg
        type: uni
        act: req
        width: 1
        inst_name: keymgr
        index: -1
      }
      {
        name: kmac_key
        struct: hw_key_req
        package: keymgr_pkg
        type: uni
        act: req
        width: 1
        inst_name: keymgr
        default: ""
        end_idx: -1
        top_type: broadcast
        top_signame: keymgr_kmac_key
        index: -1
      }
      {
        name: otbn_key
        struct: otbn_key_req
        package: keymgr_pkg
        type: uni
        act: req
        width: 1
        inst_name: keymgr
        index: -1
      }
      {
        name: kmac_data
        struct: app
        package: kmac_pkg
        type: req_rsp
        act: req
        width: 1
        inst_name: keymgr
        default: ""
        top_signame: kmac_app
        index: 0
      }
      {
        name: otp_key
        struct: otp_keymgr_key
        package: otp_ctrl_pkg
        type: uni
        act: rcv
        width: 1
        inst_name: keymgr
        default: ""
        top_signame: otp_ctrl_otp_keymgr_key
        index: -1
      }
      {
        name: otp_device_id
        struct: otp_device_id
        package: otp_ctrl_pkg
        type: uni
        act: rcv
        width: 1
        inst_name: keymgr
        default: ""
        top_signame: keymgr_otp_device_id
        index: -1
      }
      {
        name: flash
        struct: keymgr_flash
        package: flash_ctrl_pkg
        type: uni
        act: rcv
        width: 1
        inst_name: keymgr
        default: ""
        top_signame: flash_ctrl_keymgr
        index: -1
      }
      {
        name: lc_keymgr_en
        struct: lc_tx
        package: lc_ctrl_pkg
        type: uni
        act: rcv
        width: 1
        default: lc_ctrl_pkg::On
        inst_name: keymgr
        top_signame: lc_ctrl_lc_keymgr_en
        index: -1
      }
      {
        name: lc_keymgr_div
        struct: lc_keymgr_div
        package: lc_ctrl_pkg
        type: uni
        act: rcv
        width: 1
        inst_name: keymgr
        default: ""
        top_signame: lc_ctrl_lc_keymgr_div
        index: -1
      }
      {
        name: rom_digest
        struct: keymgr_data
        package: rom_ctrl_pkg
        type: uni
        act: rcv
        width: 1
        inst_name: keymgr
        default: ""
        top_signame: rom_ctrl_keymgr_data
        index: -1
      }
      {
        name: kmac_en_masking
        struct: logic
        type: uni
        act: rcv
        width: 1
        inst_name: keymgr
        default: ""
        package: ""
        top_signame: kmac_en_masking
        index: -1
      }
      {
        name: tl
        struct: tl
        package: tlul_pkg
        type: req_rsp
        act: rsp
        width: 1
        inst_name: keymgr
        default: ""
        end_idx: -1
        top_signame: keymgr_tl
        index: -1
      }
      {
        name: csrng_cmd
        struct: csrng
        package: csrng_pkg
        type: req_rsp
        act: rsp
        width: 2
        inst_name: csrng
        default: ""
        end_idx: 1
        top_type: partial-one-to-N
        top_signame: csrng_csrng_cmd
        index: -1
      }
      {
        name: entropy_src_hw_if
        struct: entropy_src_hw_if
        package: entropy_src_pkg
        type: req_rsp
        act: req
        width: 1
        inst_name: csrng
        default: ""
        end_idx: -1
        top_signame: csrng_entropy_src_hw_if
        index: -1
      }
      {
        name: cs_aes_halt
        desc:
          '''
          Coordinate activity between CSRNG's AES and Entropy Source's SHA3.
          When CSRNG gets a request and its AES is not active, it acknowledges and until the request has dropped neither runs its AES nor drops the acknowledge.
          '''
        struct: cs_aes_halt
        package: entropy_src_pkg
        type: req_rsp
        act: rsp
        width: 1
        inst_name: csrng
        default: ""
        end_idx: -1
        top_signame: csrng_cs_aes_halt
        index: -1
      }
      {
        name: otp_en_csrng_sw_app_read
        struct: mubi8
        package: prim_mubi_pkg
        type: uni
        act: rcv
        width: 1
        default: prim_mubi_pkg::MuBi8True
        inst_name: csrng
        top_signame: csrng_otp_en_csrng_sw_app_read
        index: -1
      }
      {
        name: lc_hw_debug_en
        struct: lc_tx
        package: lc_ctrl_pkg
        type: uni
        act: rcv
        width: 1
        default: lc_ctrl_pkg::Off
        inst_name: csrng
        top_signame: lc_ctrl_lc_hw_debug_en
        index: -1
      }
      {
        name: tl
        struct: tl
        package: tlul_pkg
        type: req_rsp
        act: rsp
        width: 1
        inst_name: csrng
        default: ""
        end_idx: -1
        top_signame: csrng_tl
        index: -1
      }
      {
        name: entropy_src_hw_if
        struct: entropy_src_hw_if
        package: entropy_src_pkg
        type: req_rsp
        act: rsp
        width: 1
        inst_name: entropy_src
        default: ""
        top_signame: csrng_entropy_src_hw_if
        index: -1
      }
      {
        name: cs_aes_halt
        desc:
          '''
          Coordinate activity between CSRNG's AES and Entropy Source's SHA3.
          The idea is that Entropy Source requests CSRNG's AES to halt and waits for CSRNG to acknowledge before it starts its SHA3.
          While SHA3 runs, Entropy Source keeps the request high.
          CSRNG may not drop the acknowledge before Entropy Source drops the request.
          '''
        struct: cs_aes_halt
        package: entropy_src_pkg
        type: req_rsp
        act: req
        width: 1
        inst_name: entropy_src
        default: ""
        top_signame: csrng_cs_aes_halt
        index: -1
      }
      {
        name: entropy_src_rng
        struct: entropy_src_rng
        package: entropy_src_pkg
        type: req_rsp
        act: req
        width: 1
        inst_name: entropy_src
        default: ""
        external: true
        top_signame: es_rng
        conn_type: false
        index: -1
      }
      {
        name: entropy_src_xht
        struct: entropy_src_xht
        package: entropy_src_pkg
        type: req_rsp
        act: req
        width: 1
        inst_name: entropy_src
        index: -1
      }
      {
        name: otp_en_entropy_src_fw_read
        struct: mubi8
        package: prim_mubi_pkg
        type: uni
        act: rcv
        width: 1
        default: prim_mubi_pkg::MuBi8True
        inst_name: entropy_src
        index: -1
      }
      {
        name: otp_en_entropy_src_fw_over
        struct: mubi8
        package: prim_mubi_pkg
        type: uni
        act: rcv
        width: 1
        default: prim_mubi_pkg::MuBi8True
        inst_name: entropy_src
        index: -1
      }
      {
        name: rng_fips
        struct: logic
        type: uni
        act: req
        width: 1
        inst_name: entropy_src
        default: ""
        package: ""
        external: true
        top_signame: es_rng_fips
        conn_type: false
        index: -1
      }
      {
        name: tl
        struct: tl
        package: tlul_pkg
        type: req_rsp
        act: rsp
        width: 1
        inst_name: entropy_src
        default: ""
        end_idx: -1
        top_signame: entropy_src_tl
        index: -1
      }
      {
        name: csrng_cmd
        desc: EDN supports a signal CSRNG application interface.
        struct: csrng
        package: csrng_pkg
        type: req_rsp
        act: req
        width: 1
        inst_name: edn0
        default: ""
        top_signame: csrng_csrng_cmd
        index: 0
      }
      {
        name: edn
        desc:
          '''
          The collection of peripheral ports supported by edn. The width (4)
          indicates the number of peripheral ports on a single instance.
          Due to limitations in the parametrization of top-level interconnects
          this value is not currently parameterizable.  However, the number
          of peripheral ports may change in a future revision.
          '''
        struct: edn
        package: edn_pkg
        type: req_rsp
        act: rsp
        width: 8
        default: "'0"
        inst_name: edn0
        end_idx: 6
        top_type: partial-one-to-N
        top_signame: edn0_edn
        index: -1
      }
      {
        name: tl
        struct: tl
        package: tlul_pkg
        type: req_rsp
        act: rsp
        width: 1
        inst_name: edn0
        default: ""
        end_idx: -1
        top_signame: edn0_tl
        index: -1
      }
      {
        name: sram_otp_key
        struct: sram_otp_key
        package: otp_ctrl_pkg
        type: req_rsp
        act: req
        width: 1
        inst_name: sram_ctrl_main
        default: ""
        top_signame: otp_ctrl_sram_otp_key
        index: 0
      }
      {
        name: cfg
        struct: ram_1p_cfg
        package: prim_ram_1p_pkg
        type: uni
        act: rcv
        width: 1
        default: "'0"
        inst_name: sram_ctrl_main
        top_signame: ast_ram_1p_cfg
        index: -1
      }
      {
        name: lc_escalate_en
        struct: lc_tx
        package: lc_ctrl_pkg
        type: uni
        act: rcv
        width: 1
        default: lc_ctrl_pkg::Off
        inst_name: sram_ctrl_main
        top_signame: lc_ctrl_lc_escalate_en
        index: -1
      }
      {
        name: lc_hw_debug_en
        struct: lc_tx
        package: lc_ctrl_pkg
        type: uni
        act: rcv
        width: 1
        default: lc_ctrl_pkg::Off
        inst_name: sram_ctrl_main
        top_signame: lc_ctrl_lc_hw_debug_en
        index: -1
      }
      {
        name: otp_en_sram_ifetch
        struct: mubi8
        package: prim_mubi_pkg
        type: uni
        act: rcv
        width: 1
        default: prim_mubi_pkg::MuBi8False
        inst_name: sram_ctrl_main
        top_signame: sram_ctrl_main_otp_en_sram_ifetch
        index: -1
      }
      {
        name: regs_tl
        struct: tl
        package: tlul_pkg
        type: req_rsp
        act: rsp
        width: 1
        inst_name: sram_ctrl_main
        default: ""
        end_idx: -1
        top_signame: sram_ctrl_main_regs_tl
        index: -1
      }
      {
        name: ram_tl
        struct: tl
        package: tlul_pkg
        type: req_rsp
        act: rsp
        width: 1
        inst_name: sram_ctrl_main
        default: ""
        end_idx: -1
        top_signame: sram_ctrl_main_ram_tl
        index: -1
      }
      {
        name: rom_cfg
        struct: rom_cfg
        package: prim_rom_pkg
        type: uni
        act: rcv
        width: 1
        inst_name: rom_ctrl
        default: ""
        top_signame: ast_rom_cfg
        index: -1
      }
      {
        name: pwrmgr_data
        struct: pwrmgr_data
        package: rom_ctrl_pkg
        type: uni
        act: req
        width: 1
        inst_name: rom_ctrl
        default: ""
        end_idx: -1
        top_type: broadcast
        top_signame: rom_ctrl_pwrmgr_data
        index: -1
      }
      {
        name: keymgr_data
        struct: keymgr_data
        package: rom_ctrl_pkg
        type: uni
        act: req
        width: 1
        inst_name: rom_ctrl
        default: ""
        end_idx: -1
        top_type: broadcast
        top_signame: rom_ctrl_keymgr_data
        index: -1
      }
      {
        name: kmac_data
        struct: app
        package: kmac_pkg
        type: req_rsp
        act: req
        width: 1
        inst_name: rom_ctrl
        default: ""
        top_signame: kmac_app
        index: 2
      }
      {
        name: regs_tl
        struct: tl
        package: tlul_pkg
        type: req_rsp
        act: rsp
        width: 1
        inst_name: rom_ctrl
        default: ""
        end_idx: -1
        top_signame: rom_ctrl_regs_tl
        index: -1
      }
      {
        name: rom_tl
        struct: tl
        package: tlul_pkg
        type: req_rsp
        act: rsp
        width: 1
        inst_name: rom_ctrl
        default: ""
        end_idx: -1
        top_signame: rom_ctrl_rom_tl
        index: -1
      }
      {
        name: rst_cpu_n
        struct: logic
        type: uni
        act: req
        width: 1
        inst_name: rv_core_ibex
        index: -1
      }
      {
        name: ram_cfg
        struct: ram_1p_cfg
        package: prim_ram_1p_pkg
        type: uni
        act: rcv
        width: 1
        inst_name: rv_core_ibex
        default: ""
        top_signame: ast_ram_1p_cfg
        index: -1
      }
      {
        name: hart_id
        struct: logic
        type: uni
        act: rcv
        width: 32
        inst_name: rv_core_ibex
        default: ""
        package: ""
        top_signame: rv_core_ibex_hart_id
        index: -1
      }
      {
        name: boot_addr
        struct: logic
        type: uni
        act: rcv
        width: 32
        inst_name: rv_core_ibex
        default: ""
        package: ""
        top_signame: rv_core_ibex_boot_addr
        index: -1
      }
      {
        name: irq_software
        struct: logic
        type: uni
        act: rcv
        width: 1
        inst_name: rv_core_ibex
        default: ""
        package: ""
        top_signame: rv_plic_msip
        index: -1
      }
      {
        name: irq_timer
        struct: logic
        type: uni
        act: rcv
        width: 1
        inst_name: rv_core_ibex
        default: ""
        package: ""
        top_signame: rv_core_ibex_irq_timer
        index: -1
      }
      {
        name: irq_external
        struct: logic
        type: uni
        act: rcv
        width: 1
        inst_name: rv_core_ibex
        default: ""
        package: ""
        top_signame: rv_plic_irq
        index: -1
      }
      {
        name: esc_tx
        struct: esc_tx
        package: prim_esc_pkg
        type: uni
        act: rcv
        width: 1
        inst_name: rv_core_ibex
        default: ""
        top_signame: alert_handler_esc_tx
        index: 0
      }
      {
        name: esc_rx
        struct: esc_rx
        package: prim_esc_pkg
        type: uni
        act: req
        width: 1
        inst_name: rv_core_ibex
        default: ""
        top_signame: alert_handler_esc_rx
        index: 0
      }
      {
        name: debug_req
        struct: logic
        type: uni
        act: rcv
        width: 1
        inst_name: rv_core_ibex
        default: ""
        package: ""
        top_signame: rv_dm_debug_req
        index: -1
      }
      {
        name: crash_dump
        struct: cpu_crash_dump
        package: rv_core_ibex_pkg
        type: uni
        act: req
        width: 1
        inst_name: rv_core_ibex
        default: ""
        end_idx: -1
        top_type: broadcast
        top_signame: rv_core_ibex_crash_dump
        index: -1
      }
      {
        name: lc_cpu_en
        struct: lc_tx
        package: lc_ctrl_pkg
        type: uni
        act: rcv
        width: 1
        inst_name: rv_core_ibex
        default: ""
        top_signame: lc_ctrl_lc_cpu_en
        index: -1
      }
      {
        name: pwrmgr_cpu_en
        struct: lc_tx
        package: lc_ctrl_pkg
        type: uni
        act: rcv
        width: 1
        inst_name: rv_core_ibex
        default: ""
        top_signame: pwrmgr_aon_fetch_en
        index: -1
      }
      {
        name: pwrmgr
        struct: pwr_cpu
        package: pwrmgr_pkg
        type: uni
        act: req
        width: 1
        inst_name: rv_core_ibex
        default: ""
        end_idx: -1
        top_type: broadcast
        top_signame: rv_core_ibex_pwrmgr
        index: -1
      }
      {
        name: nmi_wdog
        struct: logic
        type: uni
        act: rcv
        width: 1
        inst_name: rv_core_ibex
        default: ""
        package: ""
        top_signame: aon_timer_aon_nmi_wdog_timer_bark
        index: -1
      }
      {
        name: edn
        struct: edn
        package: edn_pkg
        type: req_rsp
        act: req
        width: 1
        inst_name: rv_core_ibex
        default: ""
        top_signame: edn0_edn
        index: 5
      }
      {
        name: icache_otp_key
        struct: sram_otp_key
        package: otp_ctrl_pkg
        type: req_rsp
        act: req
        width: 1
        inst_name: rv_core_ibex
        default: ""
        top_signame: otp_ctrl_sram_otp_key
        index: 2
      }
      {
        name: fpga_info
        struct: logic
        type: uni
        act: rcv
        width: 32
        inst_name: rv_core_ibex
        default: ""
        package: ""
        external: true
        top_signame: fpga_info
        conn_type: false
        index: -1
      }
      {
        name: corei_tl_h
        struct: tl
        package: tlul_pkg
        type: req_rsp
        act: req
        width: 1
        inst_name: rv_core_ibex
        default: ""
        top_signame: main_tl_rv_core_ibex__corei
        index: -1
      }
      {
        name: cored_tl_h
        struct: tl
        package: tlul_pkg
        type: req_rsp
        act: req
        width: 1
        inst_name: rv_core_ibex
        default: ""
        top_signame: main_tl_rv_core_ibex__cored
        index: -1
      }
      {
        name: cfg_tl_d
        struct: tl
        package: tlul_pkg
        type: req_rsp
        act: rsp
        width: 1
        inst_name: rv_core_ibex
        default: ""
        end_idx: -1
        top_signame: rv_core_ibex_cfg_tl_d
        index: -1
      }
      {
        name: tl_rv_core_ibex__corei
        struct: tl
        package: tlul_pkg
        type: req_rsp
        act: rsp
        width: 1
        inst_name: main
        default: ""
        end_idx: -1
        top_signame: main_tl_rv_core_ibex__corei
        index: -1
      }
      {
        name: tl_rv_core_ibex__cored
        struct: tl
        package: tlul_pkg
        type: req_rsp
        act: rsp
        width: 1
        inst_name: main
        default: ""
        end_idx: -1
        top_signame: main_tl_rv_core_ibex__cored
        index: -1
      }
      {
        name: tl_rv_dm__sba
        struct: tl
        package: tlul_pkg
        type: req_rsp
        act: rsp
        width: 1
        inst_name: main
        default: ""
        end_idx: -1
        top_signame: main_tl_rv_dm__sba
        index: -1
      }
      {
        name: tl_rv_dm__regs
        struct: tl
        package: tlul_pkg
        type: req_rsp
        act: req
        width: 1
        inst_name: main
        default: ""
        top_signame: rv_dm_regs_tl_d
        index: -1
      }
      {
        name: tl_rv_dm__mem
        struct: tl
        package: tlul_pkg
        type: req_rsp
        act: req
        width: 1
        inst_name: main
        default: ""
        top_signame: rv_dm_mem_tl_d
        index: -1
      }
      {
        name: tl_rom_ctrl__rom
        struct: tl
        package: tlul_pkg
        type: req_rsp
        act: req
        width: 1
        inst_name: main
        default: ""
        top_signame: rom_ctrl_rom_tl
        index: -1
      }
      {
        name: tl_rom_ctrl__regs
        struct: tl
        package: tlul_pkg
        type: req_rsp
        act: req
        width: 1
        inst_name: main
        default: ""
        top_signame: rom_ctrl_regs_tl
        index: -1
      }
      {
        name: tl_peri
        struct: tl
        package: tlul_pkg
        type: req_rsp
        act: req
        width: 1
        inst_name: main
        default: ""
        end_idx: -1
        top_signame: main_tl_peri
        index: -1
      }
      {
        name: tl_spi_host0
        struct: tl
        package: tlul_pkg
        type: req_rsp
        act: req
        width: 1
        inst_name: main
        default: ""
        top_signame: spi_host0_tl
        index: -1
      }
      {
        name: tl_flash_ctrl__core
        struct: tl
        package: tlul_pkg
        type: req_rsp
        act: req
        width: 1
        inst_name: main
        default: ""
        top_signame: flash_ctrl_core_tl
        index: -1
      }
      {
        name: tl_flash_ctrl__prim
        struct: tl
        package: tlul_pkg
        type: req_rsp
        act: req
        width: 1
        inst_name: main
        default: ""
        top_signame: flash_ctrl_prim_tl
        index: -1
      }
      {
        name: tl_flash_ctrl__mem
        struct: tl
        package: tlul_pkg
        type: req_rsp
        act: req
        width: 1
        inst_name: main
        default: ""
        top_signame: flash_ctrl_mem_tl
        index: -1
      }
      {
        name: tl_kmac
        struct: tl
        package: tlul_pkg
        type: req_rsp
        act: req
        width: 1
        inst_name: main
        default: ""
        top_signame: kmac_tl
        index: -1
      }
      {
        name: tl_entropy_src
        struct: tl
        package: tlul_pkg
        type: req_rsp
        act: req
        width: 1
        inst_name: main
        default: ""
        top_signame: entropy_src_tl
        index: -1
      }
      {
        name: tl_csrng
        struct: tl
        package: tlul_pkg
        type: req_rsp
        act: req
        width: 1
        inst_name: main
        default: ""
        top_signame: csrng_tl
        index: -1
      }
      {
        name: tl_edn0
        struct: tl
        package: tlul_pkg
        type: req_rsp
        act: req
        width: 1
        inst_name: main
        default: ""
        top_signame: edn0_tl
        index: -1
      }
      {
        name: tl_rv_plic
        struct: tl
        package: tlul_pkg
        type: req_rsp
        act: req
        width: 1
        inst_name: main
        default: ""
        top_signame: rv_plic_tl
        index: -1
      }
      {
        name: tl_keymgr
        struct: tl
        package: tlul_pkg
        type: req_rsp
        act: req
        width: 1
        inst_name: main
        default: ""
        top_signame: keymgr_tl
        index: -1
      }
      {
        name: tl_rv_core_ibex__cfg
        struct: tl
        package: tlul_pkg
        type: req_rsp
        act: req
        width: 1
        inst_name: main
        default: ""
        top_signame: rv_core_ibex_cfg_tl_d
        index: -1
      }
      {
        name: tl_sram_ctrl_main__regs
        struct: tl
        package: tlul_pkg
        type: req_rsp
        act: req
        width: 1
        inst_name: main
        default: ""
        top_signame: sram_ctrl_main_regs_tl
        index: -1
      }
      {
        name: tl_sram_ctrl_main__ram
        struct: tl
        package: tlul_pkg
        type: req_rsp
        act: req
        width: 1
        inst_name: main
        default: ""
        top_signame: sram_ctrl_main_ram_tl
        index: -1
      }
      {
        name: tl_main
        struct: tl
        package: tlul_pkg
        type: req_rsp
        act: rsp
        width: 1
        inst_name: peri
        default: ""
        top_signame: main_tl_peri
        index: -1
      }
      {
        name: tl_ergo_cdc_bridge0
        struct: tl
        package: tlul_pkg
        type: req_rsp
        act: req
        width: 1
        inst_name: peri
        default: ""
        top_signame: ergo_cdc_bridge0_tl
        index: -1
      }
      {
        name: tl_ergo_cdc_bridge1
        struct: tl
        package: tlul_pkg
        type: req_rsp
        act: req
        width: 1
        inst_name: peri
        default: ""
        top_signame: ergo_cdc_bridge1_tl
        index: -1
      }
      {
        name: tl_ergo_cdc_bridge2
        struct: tl
        package: tlul_pkg
        type: req_rsp
        act: req
        width: 1
        inst_name: peri
        default: ""
        top_signame: ergo_cdc_bridge2_tl
        index: -1
      }
      {
        name: tl_ergo_cdc_bridge3
        struct: tl
        package: tlul_pkg
        type: req_rsp
        act: req
        width: 1
        inst_name: peri
        default: ""
        top_signame: ergo_cdc_bridge3_tl
        index: -1
      }
      {
        name: tl_ergo_cdc_bridge4
        struct: tl
        package: tlul_pkg
        type: req_rsp
        act: req
        width: 1
        inst_name: peri
        default: ""
        top_signame: ergo_cdc_bridge4_tl
        index: -1
      }
      {
        name: tl_ergo_cdc_bridge5
        struct: tl
        package: tlul_pkg
        type: req_rsp
        act: req
        width: 1
        inst_name: peri
        default: ""
        top_signame: ergo_cdc_bridge5_tl
        index: -1
      }
      {
        name: tl_ergo_setup_gen0
        struct: tl
        package: tlul_pkg
        type: req_rsp
        act: req
        width: 1
        inst_name: peri
        default: ""
        top_signame: ergo_setup_gen0_tl
        index: -1
      }
      {
        name: tl_ergo_setup_gen1
        struct: tl
        package: tlul_pkg
        type: req_rsp
        act: req
        width: 1
        inst_name: peri
        default: ""
        top_signame: ergo_setup_gen1_tl
        index: -1
      }
      {
        name: tl_ergo_setup_gen2
        struct: tl
        package: tlul_pkg
        type: req_rsp
        act: req
        width: 1
        inst_name: peri
        default: ""
        top_signame: ergo_setup_gen2_tl
        index: -1
      }
      {
        name: tl_ergo_setup_gen3
        struct: tl
        package: tlul_pkg
        type: req_rsp
        act: req
        width: 1
        inst_name: peri
        default: ""
        top_signame: ergo_setup_gen3_tl
        index: -1
      }
      {
        name: tl_ergo_setup_gen4
        struct: tl
        package: tlul_pkg
        type: req_rsp
        act: req
        width: 1
        inst_name: peri
        default: ""
        top_signame: ergo_setup_gen4_tl
        index: -1
      }
      {
        name: tl_ergo_setup_gen5
        struct: tl
        package: tlul_pkg
        type: req_rsp
        act: req
        width: 1
        inst_name: peri
        default: ""
        top_signame: ergo_setup_gen5_tl
        index: -1
      }
      {
        name: tl_ergo_hold_gen0
        struct: tl
        package: tlul_pkg
        type: req_rsp
        act: req
        width: 1
        inst_name: peri
        default: ""
        top_signame: ergo_hold_gen0_tl
        index: -1
      }
      {
        name: tl_ergo_hold_gen1
        struct: tl
        package: tlul_pkg
        type: req_rsp
        act: req
        width: 1
        inst_name: peri
        default: ""
        top_signame: ergo_hold_gen1_tl
        index: -1
      }
      {
        name: tl_ergo_hold_gen2
        struct: tl
        package: tlul_pkg
        type: req_rsp
        act: req
        width: 1
        inst_name: peri
        default: ""
        top_signame: ergo_hold_gen2_tl
        index: -1
      }
      {
        name: tl_ergo_hold_gen3
        struct: tl
        package: tlul_pkg
        type: req_rsp
        act: req
        width: 1
        inst_name: peri
        default: ""
        top_signame: ergo_hold_gen3_tl
        index: -1
      }
      {
        name: tl_ergo_hold_gen4
        struct: tl
        package: tlul_pkg
        type: req_rsp
        act: req
        width: 1
        inst_name: peri
        default: ""
        top_signame: ergo_hold_gen4_tl
        index: -1
      }
      {
        name: tl_ergo_cdc_hazard_gen0
        struct: tl
        package: tlul_pkg
        type: req_rsp
        act: req
        width: 1
        inst_name: peri
        default: ""
        top_signame: ergo_cdc_hazard_gen0_tl
        index: -1
      }
      {
        name: tl_ergo_cdc_hazard_gen1
        struct: tl
        package: tlul_pkg
        type: req_rsp
        act: req
        width: 1
        inst_name: peri
        default: ""
        top_signame: ergo_cdc_hazard_gen1_tl
        index: -1
      }
      {
        name: tl_ergo_cdc_hazard_gen2
        struct: tl
        package: tlul_pkg
        type: req_rsp
        act: req
        width: 1
        inst_name: peri
        default: ""
        top_signame: ergo_cdc_hazard_gen2_tl
        index: -1
      }
      {
        name: tl_ergo_cdc_hazard_gen3
        struct: tl
        package: tlul_pkg
        type: req_rsp
        act: req
        width: 1
        inst_name: peri
        default: ""
        top_signame: ergo_cdc_hazard_gen3_tl
        index: -1
      }
      {
        name: tl_ergo_cdc_hazard_gen4
        struct: tl
        package: tlul_pkg
        type: req_rsp
        act: req
        width: 1
        inst_name: peri
        default: ""
        top_signame: ergo_cdc_hazard_gen4_tl
        index: -1
      }
      {
        name: tl_ergo_cdc_bridge6
        struct: tl
        package: tlul_pkg
        type: req_rsp
        act: req
        width: 1
        inst_name: peri
        default: ""
        top_signame: ergo_cdc_bridge6_tl
        index: -1
      }
      {
        name: tl_ergo_cdc_bridge7
        struct: tl
        package: tlul_pkg
        type: req_rsp
        act: req
        width: 1
        inst_name: peri
        default: ""
        top_signame: ergo_cdc_bridge7_tl
        index: -1
      }
      {
        name: tl_ergo_cdc_bridge8
        struct: tl
        package: tlul_pkg
        type: req_rsp
        act: req
        width: 1
        inst_name: peri
        default: ""
        top_signame: ergo_cdc_bridge8_tl
        index: -1
      }
      {
        name: tl_ergo_setup_gen6
        struct: tl
        package: tlul_pkg
        type: req_rsp
        act: req
        width: 1
        inst_name: peri
        default: ""
        top_signame: ergo_setup_gen6_tl
        index: -1
      }
      {
        name: tl_ergo_setup_gen7
        struct: tl
        package: tlul_pkg
        type: req_rsp
        act: req
        width: 1
        inst_name: peri
        default: ""
        top_signame: ergo_setup_gen7_tl
        index: -1
      }
      {
        name: tl_ergo_setup_gen8
        struct: tl
        package: tlul_pkg
        type: req_rsp
        act: req
        width: 1
        inst_name: peri
        default: ""
        top_signame: ergo_setup_gen8_tl
        index: -1
      }
      {
        name: tl_ergo_hold_gen5
        struct: tl
        package: tlul_pkg
        type: req_rsp
        act: req
        width: 1
        inst_name: peri
        default: ""
        top_signame: ergo_hold_gen5_tl
        index: -1
      }
      {
        name: tl_ergo_hold_gen6
        struct: tl
        package: tlul_pkg
        type: req_rsp
        act: req
        width: 1
        inst_name: peri
        default: ""
        top_signame: ergo_hold_gen6_tl
        index: -1
      }
      {
        name: tl_ergo_cdc_hazard_gen5
        struct: tl
        package: tlul_pkg
        type: req_rsp
        act: req
        width: 1
        inst_name: peri
        default: ""
        top_signame: ergo_cdc_hazard_gen5_tl
        index: -1
      }
      {
        name: tl_ergo_cdc_hazard_gen6
        struct: tl
        package: tlul_pkg
        type: req_rsp
        act: req
        width: 1
        inst_name: peri
        default: ""
        top_signame: ergo_cdc_hazard_gen6_tl
        index: -1
      }
      {
        name: tl_uart0
        struct: tl
        package: tlul_pkg
        type: req_rsp
        act: req
        width: 1
        inst_name: peri
        default: ""
        top_signame: uart0_tl
        index: -1
      }
      {
        name: tl_i2c0
        struct: tl
        package: tlul_pkg
        type: req_rsp
        act: req
        width: 1
        inst_name: peri
        default: ""
        top_signame: i2c0_tl
        index: -1
      }
      {
        name: tl_gpio
        struct: tl
        package: tlul_pkg
        type: req_rsp
        act: req
        width: 1
        inst_name: peri
        default: ""
        top_signame: gpio_tl
        index: -1
      }
      {
        name: tl_spi_device
        struct: tl
        package: tlul_pkg
        type: req_rsp
        act: req
        width: 1
        inst_name: peri
        default: ""
        top_signame: spi_device_tl
        index: -1
      }
      {
        name: tl_rv_timer
        struct: tl
        package: tlul_pkg
        type: req_rsp
        act: req
        width: 1
        inst_name: peri
        default: ""
        top_signame: rv_timer_tl
        index: -1
      }
      {
        name: tl_pwrmgr_aon
        struct: tl
        package: tlul_pkg
        type: req_rsp
        act: req
        width: 1
        inst_name: peri
        default: ""
        top_signame: pwrmgr_aon_tl
        index: -1
      }
      {
        name: tl_rstmgr_aon
        struct: tl
        package: tlul_pkg
        type: req_rsp
        act: req
        width: 1
        inst_name: peri
        default: ""
        top_signame: rstmgr_aon_tl
        index: -1
      }
      {
        name: tl_clkmgr_aon
        struct: tl
        package: tlul_pkg
        type: req_rsp
        act: req
        width: 1
        inst_name: peri
        default: ""
        top_signame: clkmgr_aon_tl
        index: -1
      }
      {
        name: tl_pinmux_aon
        struct: tl
        package: tlul_pkg
        type: req_rsp
        act: req
        width: 1
        inst_name: peri
        default: ""
        top_signame: pinmux_aon_tl
        index: -1
      }
      {
        name: tl_otp_ctrl__core
        struct: tl
        package: tlul_pkg
        type: req_rsp
        act: req
        width: 1
        inst_name: peri
        default: ""
        top_signame: otp_ctrl_core_tl
        index: -1
      }
      {
        name: tl_otp_ctrl__prim
        struct: tl
        package: tlul_pkg
        type: req_rsp
        act: req
        width: 1
        inst_name: peri
        default: ""
        top_signame: otp_ctrl_prim_tl
        index: -1
      }
      {
        name: tl_lc_ctrl
        struct: tl
        package: tlul_pkg
        type: req_rsp
        act: req
        width: 1
        inst_name: peri
        default: ""
        top_signame: lc_ctrl_tl
        index: -1
      }
      {
        name: tl_alert_handler
        struct: tl
        package: tlul_pkg
        type: req_rsp
        act: req
        width: 1
        inst_name: peri
        default: ""
        top_signame: alert_handler_tl
        index: -1
      }
      {
        name: tl_sram_ctrl_ret_aon__regs
        struct: tl
        package: tlul_pkg
        type: req_rsp
        act: req
        width: 1
        inst_name: peri
        default: ""
        top_signame: sram_ctrl_ret_aon_regs_tl
        index: -1
      }
      {
        name: tl_sram_ctrl_ret_aon__ram
        struct: tl
        package: tlul_pkg
        type: req_rsp
        act: req
        width: 1
        inst_name: peri
        default: ""
        top_signame: sram_ctrl_ret_aon_ram_tl
        index: -1
      }
      {
        name: tl_aon_timer_aon
        struct: tl
        package: tlul_pkg
        type: req_rsp
        act: req
        width: 1
        inst_name: peri
        default: ""
        top_signame: aon_timer_aon_tl
        index: -1
      }
      {
        name: tl_ast
        struct: tl
        package: tlul_pkg
        type: req_rsp
        act: req
        width: 1
        inst_name: peri
        default: ""
        external: true
        top_signame: ast_tl
        conn_type: false
        index: -1
      }
      {
        struct: edn
        type: req_rsp
        name: edn
        act: rsp
        package: edn_pkg
        inst_name: ast
        width: 1
        default: ""
        top_signame: edn0_edn
        index: 2
        external: true
        conn_type: true
      }
      {
        struct: lc_tx
        type: uni
        name: lc_dft_en
        act: req
        package: lc_ctrl_pkg
        inst_name: ast
        width: 1
        default: ""
        top_signame: lc_ctrl_lc_dft_en
        index: -1
        external: true
        conn_type: true
      }
      {
        struct: ram_1p_cfg
        package: prim_ram_1p_pkg
        type: uni
        name: ram_1p_cfg
        act: rcv
        inst_name: ast
        width: 1
        default: ""
        end_idx: -1
        top_type: broadcast
        top_signame: ast_ram_1p_cfg
        index: -1
        external: true
        conn_type: true
      }
      {
        struct: ram_2p_cfg
        package: prim_ram_2p_pkg
        type: uni
        name: spi_ram_2p_cfg
        act: rcv
        inst_name: ast
        width: 1
        default: ""
        end_idx: -1
        top_type: broadcast
        top_signame: ast_spi_ram_2p_cfg
        index: -1
        external: true
        conn_type: true
      }
      {
        struct: ram_1p_cfg
        package: prim_ram_1p_pkg
        type: uni
        name: usb_ram_1p_cfg
        act: rcv
        inst_name: ast
        index: -1
      }
      {
        struct: rom_cfg
        package: prim_rom_pkg
        type: uni
        name: rom_cfg
        act: rcv
        inst_name: ast
        width: 1
        default: ""
        end_idx: -1
        top_type: broadcast
        top_signame: ast_rom_cfg
        index: -1
        external: true
        conn_type: true
      }
      {
        struct: ast_obs_ctrl
        type: uni
        name: obs_ctrl
        act: rcv
        package: ast_pkg
        inst_name: ast
        width: 1
        default: ""
        end_idx: -1
        top_type: broadcast
        top_signame: ast_obs_ctrl
        index: -1
        external: true
        conn_type: true
      }
    ]
    external:
    [
      {
        package: edn_pkg
        struct: edn_req
        signame: ast_edn_req_i
        width: 1
        type: req_rsp
        default: ""
        direction: in
        conn_type: true
        index: 2
        netname: edn0_edn_req
      }
      {
        package: edn_pkg
        struct: edn_rsp
        signame: ast_edn_rsp_o
        width: 1
        type: req_rsp
        default: ""
        direction: out
        conn_type: true
        index: 2
        netname: edn0_edn_rsp
      }
      {
        package: lc_ctrl_pkg
        struct: lc_tx
        signame: ast_lc_dft_en_o
        width: 1
        type: uni
        default: ""
        direction: out
        conn_type: true
        index: -1
        netname: lc_ctrl_lc_dft_en
      }
      {
        package: ast_pkg
        struct: ast_obs_ctrl
        signame: obs_ctrl_i
        width: 1
        type: uni
        default: ""
        direction: in
        conn_type: true
        index: -1
        netname: ast_obs_ctrl
      }
      {
        package: prim_ram_1p_pkg
        struct: ram_1p_cfg
        signame: ram_1p_cfg_i
        width: 1
        type: uni
        default: ""
        direction: in
        conn_type: true
        index: -1
        netname: ast_ram_1p_cfg
      }
      {
        package: prim_ram_2p_pkg
        struct: ram_2p_cfg
        signame: spi_ram_2p_cfg_i
        width: 1
        type: uni
        default: ""
        direction: in
        conn_type: true
        index: -1
        netname: ast_spi_ram_2p_cfg
      }
      {
        package: prim_rom_pkg
        struct: rom_cfg
        signame: rom_cfg_i
        width: 1
        type: uni
        default: ""
        direction: in
        conn_type: true
        index: -1
        netname: ast_rom_cfg
      }
      {
        package: prim_mubi_pkg
        struct: mubi4
        signame: clk_main_jitter_en_o
        width: 1
        type: uni
        default: ""
        direction: out
        conn_type: false
        index: -1
        netname: clk_main_jitter_en
      }
      {
        package: prim_mubi_pkg
        struct: mubi4
        signame: io_clk_byp_req_o
        width: 1
        type: uni
        default: ""
        direction: out
        conn_type: false
        index: -1
        netname: io_clk_byp_req
      }
      {
        package: prim_mubi_pkg
        struct: mubi4
        signame: io_clk_byp_ack_i
        width: 1
        type: uni
        default: ""
        direction: in
        conn_type: false
        index: -1
        netname: io_clk_byp_ack
      }
      {
        package: prim_mubi_pkg
        struct: mubi4
        signame: all_clk_byp_req_o
        width: 1
        type: uni
        default: ""
        direction: out
        conn_type: false
        index: -1
        netname: all_clk_byp_req
      }
      {
        package: prim_mubi_pkg
        struct: mubi4
        signame: all_clk_byp_ack_i
        width: 1
        type: uni
        default: ""
        direction: in
        conn_type: false
        index: -1
        netname: all_clk_byp_ack
      }
      {
        package: prim_mubi_pkg
        struct: mubi4
        signame: hi_speed_sel_o
        width: 1
        type: uni
        default: ""
        direction: out
        conn_type: false
        index: -1
        netname: hi_speed_sel
      }
      {
        package: prim_mubi_pkg
        struct: mubi4
        signame: div_step_down_req_i
        width: 1
        type: uni
        default: ""
        direction: in
        conn_type: false
        index: -1
        netname: div_step_down_req
      }
      {
        package: prim_mubi_pkg
        struct: mubi4
        signame: calib_rdy_i
        width: 1
        type: uni
        default: prim_mubi_pkg::MuBi4True
        direction: in
        conn_type: false
        index: -1
        netname: calib_rdy
      }
      {
        package: prim_mubi_pkg
        struct: mubi4
        signame: flash_bist_enable_i
        width: 1
        type: uni
        default: ""
        direction: in
        conn_type: false
        index: -1
        netname: flash_bist_enable
      }
      {
        package: ""
        struct: logic
        signame: flash_power_down_h_i
        width: 1
        type: uni
        default: ""
        direction: in
        conn_type: false
        index: -1
        netname: flash_power_down_h
      }
      {
        package: ""
        struct: logic
        signame: flash_power_ready_h_i
        width: 1
        type: uni
        default: ""
        direction: in
        conn_type: false
        index: -1
        netname: flash_power_ready_h
      }
      {
        package: ""
        struct: ""
        signame: flash_test_mode_a_io
        width: 2
        type: io
        default: ""
        direction: inout
        conn_type: false
        index: -1
        netname: flash_test_mode_a
      }
      {
        package: ""
        struct: ""
        signame: flash_test_voltage_h_io
        width: 1
        type: io
        default: ""
        direction: inout
        conn_type: false
        index: -1
        netname: flash_test_voltage_h
      }
      {
        package: ""
        struct: logic
        signame: flash_obs_o
        width: 8
        type: uni
        default: ""
        direction: out
        conn_type: false
        index: -1
        netname: flash_obs
      }
      {
        package: entropy_src_pkg
        struct: entropy_src_rng_req
        signame: es_rng_req_o
        width: 1
        type: req_rsp
        default: ""
        direction: out
        conn_type: false
        index: -1
        netname: es_rng_req
      }
      {
        package: entropy_src_pkg
        struct: entropy_src_rng_rsp
        signame: es_rng_rsp_i
        width: 1
        type: req_rsp
        default: ""
        direction: in
        conn_type: false
        index: -1
        netname: es_rng_rsp
      }
      {
        package: ""
        struct: logic
        signame: es_rng_fips_o
        width: 1
        type: uni
        default: ""
        direction: out
        conn_type: false
        index: -1
        netname: es_rng_fips
      }
      {
        package: tlul_pkg
        struct: tl_h2d
        signame: ast_tl_req_o
        width: 1
        type: req_rsp
        default: ""
        direction: out
        conn_type: false
        index: -1
        netname: ast_tl_h2d
      }
      {
        package: tlul_pkg
        struct: tl_d2h
        signame: ast_tl_rsp_i
        width: 1
        type: req_rsp
        default: ""
        direction: in
        conn_type: false
        index: -1
        netname: ast_tl_d2h
      }
      {
        package: pinmux_pkg
        struct: dft_strap_test_req
        signame: dft_strap_test_o
        width: 1
        type: uni
        default: "'0"
        direction: out
        conn_type: false
        index: -1
        netname: dft_strap_test
      }
      {
        package: ""
        struct: logic
        signame: dft_hold_tap_sel_i
        width: 1
        type: uni
        default: "'0"
        direction: in
        conn_type: false
        index: -1
        netname: dft_hold_tap_sel
      }
      {
        package: ""
        struct: logic
        signame: usb_dp_pullup_en_o
        width: 1
        type: uni
        default: 1'b0
        direction: out
        conn_type: false
        index: -1
        netname: usb_dp_pullup_en
      }
      {
        package: ""
        struct: logic
        signame: usb_dn_pullup_en_o
        width: 1
        type: uni
        default: 1'b0
        direction: out
        conn_type: false
        index: -1
        netname: usb_dn_pullup_en
      }
      {
        package: pwrmgr_pkg
        struct: pwr_ast_req
        signame: pwrmgr_ast_req_o
        width: 1
        type: req_rsp
        default: ""
        direction: out
        conn_type: false
        index: -1
        netname: pwrmgr_ast_req
      }
      {
        package: pwrmgr_pkg
        struct: pwr_ast_rsp
        signame: pwrmgr_ast_rsp_i
        width: 1
        type: req_rsp
        default: ""
        direction: in
        conn_type: false
        index: -1
        netname: pwrmgr_ast_rsp
      }
      {
        package: otp_ctrl_pkg
        struct: otp_ast_req
        signame: otp_ctrl_otp_ast_pwr_seq_o
        width: 1
        type: uni
        default: "'0"
        direction: out
        conn_type: false
        index: -1
        netname: otp_ctrl_otp_ast_pwr_seq
      }
      {
        package: otp_ctrl_pkg
        struct: otp_ast_rsp
        signame: otp_ctrl_otp_ast_pwr_seq_h_i
        width: 1
        type: uni
        default: "'0"
        direction: in
        conn_type: false
        index: -1
        netname: otp_ctrl_otp_ast_pwr_seq_h
      }
      {
        package: ""
        struct: ""
        signame: otp_ext_voltage_h_io
        width: 1
        type: io
        default: "'0"
        direction: inout
        conn_type: false
        index: -1
        netname: otp_ext_voltage_h
      }
      {
        package: ""
        struct: logic
        signame: otp_obs_o
        width: 8
        type: uni
        default: ""
        direction: out
        conn_type: false
        index: -1
        netname: otp_obs
      }
      {
        package: ""
        struct: logic
        signame: por_n_i
        width: 2
        type: uni
        default: ""
        direction: in
        conn_type: false
        index: -1
        netname: por_n
      }
      {
        package: ""
        struct: logic
        signame: fpga_info_i
        width: 32
        type: uni
        default: ""
        direction: in
        conn_type: false
        index: -1
        netname: fpga_info
      }
      {
        package: ""
        struct: logic
        signame: sck_monitor_o
        width: 1
        type: uni
        default: ""
        direction: out
        conn_type: false
        index: -1
        netname: sck_monitor
      }
    ]
    definitions:
    [
      {
        package: ast_pkg
        struct: ast_obs_ctrl
        signame: ast_obs_ctrl
        width: 1
        type: uni
        end_idx: -1
        act: rcv
        suffix: ""
        default: ast_pkg::AST_OBS_CTRL_DEFAULT
      }
      {
        package: prim_ram_1p_pkg
        struct: ram_1p_cfg
        signame: ast_ram_1p_cfg
        width: 1
        type: uni
        end_idx: -1
        act: rcv
        suffix: ""
        default: prim_ram_1p_pkg::RAM_1P_CFG_DEFAULT
      }
      {
        package: prim_ram_2p_pkg
        struct: ram_2p_cfg
        signame: ast_spi_ram_2p_cfg
        width: 1
        type: uni
        end_idx: -1
        act: rcv
        suffix: ""
        default: prim_ram_2p_pkg::RAM_2P_CFG_DEFAULT
      }
      {
        package: prim_rom_pkg
        struct: rom_cfg
        signame: ast_rom_cfg
        width: 1
        type: uni
        end_idx: -1
        act: rcv
        suffix: ""
        default: prim_rom_pkg::ROM_CFG_DEFAULT
      }
      {
        package: alert_pkg
        struct: alert_crashdump
        signame: alert_handler_crashdump
        width: 1
        type: uni
        end_idx: -1
        act: req
        suffix: ""
        default: alert_pkg::ALERT_CRASHDUMP_DEFAULT
      }
      {
        package: prim_esc_pkg
        struct: esc_rx
        signame: alert_handler_esc_rx
        width: 4
        type: uni
        end_idx: -1
        act: rcv
        suffix: ""
        default: prim_esc_pkg::ESC_RX_DEFAULT
      }
      {
        package: prim_esc_pkg
        struct: esc_tx
        signame: alert_handler_esc_tx
        width: 4
        type: uni
        end_idx: -1
        act: req
        suffix: ""
        default: prim_esc_pkg::ESC_TX_DEFAULT
      }
      {
        package: ""
        struct: logic
        signame: aon_timer_aon_nmi_wdog_timer_bark
        width: 1
        type: uni
        end_idx: -1
        act: req
        suffix: ""
        default: 1'b0
      }
      {
        package: csrng_pkg
        struct: csrng_req
        signame: csrng_csrng_cmd_req
        width: 2
        type: req_rsp
        end_idx: 1
        act: rsp
        suffix: req
        default: csrng_pkg::CSRNG_REQ_DEFAULT
      }
      {
        package: csrng_pkg
        struct: csrng_rsp
        signame: csrng_csrng_cmd_rsp
        width: 2
        type: req_rsp
        end_idx: 1
        act: rsp
        suffix: rsp
        default: ""
      }
      {
        package: entropy_src_pkg
        struct: entropy_src_hw_if_req
        signame: csrng_entropy_src_hw_if_req
        width: 1
        type: req_rsp
        end_idx: -1
        act: req
        suffix: req
        default: ""
      }
      {
        package: entropy_src_pkg
        struct: entropy_src_hw_if_rsp
        signame: csrng_entropy_src_hw_if_rsp
        width: 1
        type: req_rsp
        end_idx: -1
        act: req
        suffix: rsp
        default: entropy_src_pkg::ENTROPY_SRC_HW_IF_RSP_DEFAULT
      }
      {
        package: entropy_src_pkg
        struct: cs_aes_halt_req
        signame: csrng_cs_aes_halt_req
        width: 1
        type: req_rsp
        end_idx: -1
        act: rsp
        suffix: req
        default: entropy_src_pkg::CS_AES_HALT_REQ_DEFAULT
      }
      {
        package: entropy_src_pkg
        struct: cs_aes_halt_rsp
        signame: csrng_cs_aes_halt_rsp
        width: 1
        type: req_rsp
        end_idx: -1
        act: rsp
        suffix: rsp
        default: ""
      }
      {
        package: flash_ctrl_pkg
        struct: keymgr_flash
        signame: flash_ctrl_keymgr
        width: 1
        type: uni
        end_idx: -1
        act: req
        suffix: ""
        default: flash_ctrl_pkg::KEYMGR_FLASH_DEFAULT
      }
      {
        package: otp_ctrl_pkg
        struct: flash_otp_key_req
        signame: flash_ctrl_otp_req
        width: 1
        type: req_rsp
        end_idx: -1
        act: req
        suffix: req
        default: ""
      }
      {
        package: otp_ctrl_pkg
        struct: flash_otp_key_rsp
        signame: flash_ctrl_otp_rsp
        width: 1
        type: req_rsp
        end_idx: -1
        act: req
        suffix: rsp
        default: otp_ctrl_pkg::FLASH_OTP_KEY_RSP_DEFAULT
      }
      {
        package: lc_ctrl_pkg
        struct: lc_flash_rma_seed
        signame: flash_ctrl_rma_seed
        width: 1
        type: uni
        end_idx: -1
        act: rcv
        suffix: ""
        default: lc_ctrl_pkg::LC_FLASH_RMA_SEED_DEFAULT
      }
      {
        package: otp_ctrl_pkg
        struct: sram_otp_key_req
        signame: otp_ctrl_sram_otp_key_req
        width: 4
        type: req_rsp
        end_idx: 3
        act: rsp
        suffix: req
        default: "'0"
      }
      {
        package: otp_ctrl_pkg
        struct: sram_otp_key_rsp
        signame: otp_ctrl_sram_otp_key_rsp
        width: 4
        type: req_rsp
        end_idx: 3
        act: rsp
        suffix: rsp
        default: ""
      }
      {
        package: pwrmgr_pkg
        struct: pwr_flash
        signame: pwrmgr_aon_pwr_flash
        width: 1
        type: uni
        end_idx: -1
        act: rcv
        suffix: ""
        default: pwrmgr_pkg::PWR_FLASH_DEFAULT
      }
      {
        package: pwrmgr_pkg
        struct: pwr_rst_req
        signame: pwrmgr_aon_pwr_rst_req
        width: 1
        type: req_rsp
        end_idx: -1
        act: req
        suffix: req
        default: ""
      }
      {
        package: pwrmgr_pkg
        struct: pwr_rst_rsp
        signame: pwrmgr_aon_pwr_rst_rsp
        width: 1
        type: req_rsp
        end_idx: -1
        act: req
        suffix: rsp
        default: pwrmgr_pkg::PWR_RST_RSP_DEFAULT
      }
      {
        package: pwrmgr_pkg
        struct: pwr_clk_req
        signame: pwrmgr_aon_pwr_clk_req
        width: 1
        type: req_rsp
        end_idx: -1
        act: req
        suffix: req
        default: ""
      }
      {
        package: pwrmgr_pkg
        struct: pwr_clk_rsp
        signame: pwrmgr_aon_pwr_clk_rsp
        width: 1
        type: req_rsp
        end_idx: -1
        act: req
        suffix: rsp
        default: pwrmgr_pkg::PWR_CLK_RSP_DEFAULT
      }
      {
        package: pwrmgr_pkg
        struct: pwr_otp_req
        signame: pwrmgr_aon_pwr_otp_req
        width: 1
        type: req_rsp
        end_idx: -1
        act: req
        suffix: req
        default: ""
      }
      {
        package: pwrmgr_pkg
        struct: pwr_otp_rsp
        signame: pwrmgr_aon_pwr_otp_rsp
        width: 1
        type: req_rsp
        end_idx: -1
        act: req
        suffix: rsp
        default: pwrmgr_pkg::PWR_OTP_RSP_DEFAULT
      }
      {
        package: pwrmgr_pkg
        struct: pwr_lc_req
        signame: pwrmgr_aon_pwr_lc_req
        width: 1
        type: req_rsp
        end_idx: -1
        act: req
        suffix: req
        default: ""
      }
      {
        package: pwrmgr_pkg
        struct: pwr_lc_rsp
        signame: pwrmgr_aon_pwr_lc_rsp
        width: 1
        type: req_rsp
        end_idx: -1
        act: req
        suffix: rsp
        default: pwrmgr_pkg::PWR_LC_RSP_DEFAULT
      }
      {
        package: ""
        struct: logic
        signame: pwrmgr_aon_strap
        width: 1
        type: uni
        end_idx: -1
        act: req
        suffix: ""
        default: "'0"
      }
      {
        package: ""
        struct: logic
        signame: pwrmgr_aon_low_power
        width: 1
        type: uni
        end_idx: -1
        act: req
        suffix: ""
        default: "'0"
      }
      {
        package: lc_ctrl_pkg
        struct: lc_tx
        signame: pwrmgr_aon_fetch_en
        width: 1
        type: uni
        end_idx: -1
        act: req
        suffix: ""
        default: lc_ctrl_pkg::LC_TX_DEFAULT
      }
      {
        package: rom_ctrl_pkg
        struct: pwrmgr_data
        signame: rom_ctrl_pwrmgr_data
        width: 1
        type: uni
        end_idx: -1
        act: req
        suffix: ""
        default: rom_ctrl_pkg::PWRMGR_DATA_DEFAULT
      }
      {
        package: rom_ctrl_pkg
        struct: keymgr_data
        signame: rom_ctrl_keymgr_data
        width: 1
        type: uni
        end_idx: -1
        act: req
        suffix: ""
        default: rom_ctrl_pkg::KEYMGR_DATA_DEFAULT
      }
      {
        package: lc_ctrl_pkg
        struct: lc_tx
        signame: lc_ctrl_lc_flash_rma_req
        width: 1
        type: uni
        end_idx: -1
        act: req
        suffix: ""
        default: lc_ctrl_pkg::Off
      }
      {
        package: lc_ctrl_pkg
        struct: lc_tx
        signame: lc_ctrl_lc_flash_rma_ack
        width: 2
        type: uni
        end_idx: 1
        act: rcv
        suffix: ""
        default: lc_ctrl_pkg::On
      }
      {
        package: edn_pkg
        struct: edn_req
        signame: edn0_edn_req
        width: 8
        type: req_rsp
        end_idx: 6
        act: rsp
        suffix: req
        default: "'0"
      }
      {
        package: edn_pkg
        struct: edn_rsp
        signame: edn0_edn_rsp
        width: 8
        type: req_rsp
        end_idx: 6
        act: rsp
        suffix: rsp
        default: ""
      }
      {
        package: otp_ctrl_pkg
        struct: otp_keymgr_key
        signame: otp_ctrl_otp_keymgr_key
        width: 1
        type: uni
        end_idx: -1
        act: req
        suffix: ""
        default: "'0"
      }
      {
        package: keymgr_pkg
        struct: hw_key_req
        signame: keymgr_kmac_key
        width: 1
        type: uni
        end_idx: -1
        act: req
        suffix: ""
        default: keymgr_pkg::HW_KEY_REQ_DEFAULT
      }
      {
        package: kmac_pkg
        struct: app_req
        signame: kmac_app_req
        width: 3
        type: req_rsp
        end_idx: -1
        act: rsp
        suffix: req
        default: kmac_pkg::APP_REQ_DEFAULT
      }
      {
        package: kmac_pkg
        struct: app_rsp
        signame: kmac_app_rsp
        width: 3
        type: req_rsp
        end_idx: -1
        act: rsp
        suffix: rsp
        default: ""
      }
      {
        package: ""
        struct: logic
        signame: kmac_en_masking
        width: 1
        type: uni
        end_idx: -1
        act: req
        suffix: ""
        default: "'0"
      }
      {
        package: prim_mubi_pkg
        struct: mubi4
        signame: clkmgr_aon_idle
        width: 1
        type: uni
        end_idx: -1
        act: rcv
        suffix: ""
        default: prim_mubi_pkg::MUBI4_DEFAULT
      }
      {
        package: jtag_pkg
        struct: jtag_req
        signame: pinmux_aon_lc_jtag_req
        width: 1
        type: req_rsp
        end_idx: -1
        act: req
        suffix: req
        default: ""
      }
      {
        package: jtag_pkg
        struct: jtag_rsp
        signame: pinmux_aon_lc_jtag_rsp
        width: 1
        type: req_rsp
        end_idx: -1
        act: req
        suffix: rsp
        default: jtag_pkg::JTAG_RSP_DEFAULT
      }
      {
        package: jtag_pkg
        struct: jtag_req
        signame: pinmux_aon_rv_jtag_req
        width: 1
        type: req_rsp
        end_idx: -1
        act: req
        suffix: req
        default: ""
      }
      {
        package: jtag_pkg
        struct: jtag_rsp
        signame: pinmux_aon_rv_jtag_rsp
        width: 1
        type: req_rsp
        end_idx: -1
        act: req
        suffix: rsp
        default: jtag_pkg::JTAG_RSP_DEFAULT
      }
      {
        package: lc_ctrl_pkg
        struct: lc_tx
        signame: pinmux_aon_pinmux_hw_debug_en
        width: 1
        type: uni
        end_idx: -1
        act: req
        suffix: ""
        default: lc_ctrl_pkg::Off
      }
      {
        package: otp_ctrl_pkg
        struct: otp_lc_data
        signame: otp_ctrl_otp_lc_data
        width: 1
        type: uni
        end_idx: -1
        act: req
        suffix: ""
        default: "'0"
      }
      {
        package: otp_ctrl_pkg
        struct: lc_otp_program_req
        signame: lc_ctrl_lc_otp_program_req
        width: 1
        type: req_rsp
        end_idx: -1
        act: req
        suffix: req
        default: ""
      }
      {
        package: otp_ctrl_pkg
        struct: lc_otp_program_rsp
        signame: lc_ctrl_lc_otp_program_rsp
        width: 1
        type: req_rsp
        end_idx: -1
        act: req
        suffix: rsp
        default: "'0"
      }
      {
        package: otp_ctrl_pkg
        struct: lc_otp_vendor_test_req
        signame: lc_ctrl_lc_otp_vendor_test_req
        width: 1
        type: req_rsp
        end_idx: -1
        act: req
        suffix: req
        default: ""
      }
      {
        package: otp_ctrl_pkg
        struct: lc_otp_vendor_test_rsp
        signame: lc_ctrl_lc_otp_vendor_test_rsp
        width: 1
        type: req_rsp
        end_idx: -1
        act: req
        suffix: rsp
        default: "'0"
      }
      {
        package: lc_ctrl_pkg
        struct: lc_keymgr_div
        signame: lc_ctrl_lc_keymgr_div
        width: 1
        type: uni
        end_idx: -1
        act: req
        suffix: ""
        default: "'0"
      }
      {
        package: ""
        struct: logic
        signame: lc_ctrl_strap_en_override
        width: 1
        type: uni
        end_idx: -1
        act: req
        suffix: ""
        default: 1'b0
      }
      {
        package: lc_ctrl_pkg
        struct: lc_tx
        signame: lc_ctrl_lc_dft_en
        width: 1
        type: uni
        end_idx: -1
        act: req
        suffix: ""
        default: lc_ctrl_pkg::Off
      }
      {
        package: lc_ctrl_pkg
        struct: lc_tx
        signame: lc_ctrl_lc_nvm_debug_en
        width: 1
        type: uni
        end_idx: -1
        act: req
        suffix: ""
        default: lc_ctrl_pkg::Off
      }
      {
        package: lc_ctrl_pkg
        struct: lc_tx
        signame: lc_ctrl_lc_hw_debug_en
        width: 1
        type: uni
        end_idx: -1
        act: req
        suffix: ""
        default: lc_ctrl_pkg::Off
      }
      {
        package: lc_ctrl_pkg
        struct: lc_tx
        signame: lc_ctrl_lc_cpu_en
        width: 1
        type: uni
        end_idx: -1
        act: req
        suffix: ""
        default: lc_ctrl_pkg::Off
      }
      {
        package: lc_ctrl_pkg
        struct: lc_tx
        signame: lc_ctrl_lc_keymgr_en
        width: 1
        type: uni
        end_idx: -1
        act: req
        suffix: ""
        default: lc_ctrl_pkg::Off
      }
      {
        package: lc_ctrl_pkg
        struct: lc_tx
        signame: lc_ctrl_lc_escalate_en
        width: 1
        type: uni
        end_idx: -1
        act: req
        suffix: ""
        default: lc_ctrl_pkg::Off
      }
      {
        package: lc_ctrl_pkg
        struct: lc_tx
        signame: lc_ctrl_lc_check_byp_en
        width: 1
        type: uni
        end_idx: -1
        act: req
        suffix: ""
        default: lc_ctrl_pkg::Off
      }
      {
        package: lc_ctrl_pkg
        struct: lc_tx
        signame: lc_ctrl_lc_clk_byp_req
        width: 1
        type: uni
        end_idx: -1
        act: req
        suffix: ""
        default: lc_ctrl_pkg::Off
      }
      {
        package: lc_ctrl_pkg
        struct: lc_tx
        signame: lc_ctrl_lc_clk_byp_ack
        width: 1
        type: uni
        end_idx: -1
        act: rcv
        suffix: ""
        default: lc_ctrl_pkg::Off
      }
      {
        package: lc_ctrl_pkg
        struct: lc_tx
        signame: lc_ctrl_lc_creator_seed_sw_rw_en
        width: 1
        type: uni
        end_idx: -1
        act: req
        suffix: ""
        default: lc_ctrl_pkg::Off
      }
      {
        package: lc_ctrl_pkg
        struct: lc_tx
        signame: lc_ctrl_lc_owner_seed_sw_rw_en
        width: 1
        type: uni
        end_idx: -1
        act: req
        suffix: ""
        default: lc_ctrl_pkg::Off
      }
      {
        package: lc_ctrl_pkg
        struct: lc_tx
        signame: lc_ctrl_lc_iso_part_sw_rd_en
        width: 1
        type: uni
        end_idx: -1
        act: req
        suffix: ""
        default: lc_ctrl_pkg::Off
      }
      {
        package: lc_ctrl_pkg
        struct: lc_tx
        signame: lc_ctrl_lc_iso_part_sw_wr_en
        width: 1
        type: uni
        end_idx: -1
        act: req
        suffix: ""
        default: lc_ctrl_pkg::Off
      }
      {
        package: lc_ctrl_pkg
        struct: lc_tx
        signame: lc_ctrl_lc_seed_hw_rd_en
        width: 1
        type: uni
        end_idx: -1
        act: req
        suffix: ""
        default: lc_ctrl_pkg::Off
      }
      {
        package: ""
        struct: logic
        signame: rv_plic_msip
        width: 1
        type: uni
        end_idx: -1
        act: req
        suffix: ""
        default: "'0"
      }
      {
        package: ""
        struct: logic
        signame: rv_plic_irq
        width: 1
        type: uni
        end_idx: -1
        act: req
        suffix: ""
        default: "'0"
      }
      {
        package: ""
        struct: logic [rv_dm_reg_pkg::NrHarts-1:0]
        signame: rv_dm_debug_req
        width: 1
        type: uni
        end_idx: -1
        act: req
        suffix: ""
        default: "'0"
      }
      {
        package: rv_core_ibex_pkg
        struct: cpu_crash_dump
        signame: rv_core_ibex_crash_dump
        width: 1
        type: uni
        end_idx: -1
        act: req
        suffix: ""
        default: rv_core_ibex_pkg::CPU_CRASH_DUMP_DEFAULT
      }
      {
        package: pwrmgr_pkg
        struct: pwr_cpu
        signame: rv_core_ibex_pwrmgr
        width: 1
        type: uni
        end_idx: -1
        act: req
        suffix: ""
        default: pwrmgr_pkg::PWR_CPU_DEFAULT
      }
      {
        package: spi_device_pkg
        struct: passthrough_req
        signame: spi_device_passthrough_req
        width: 1
        type: req_rsp
        end_idx: -1
        act: req
        suffix: req
        default: ""
      }
      {
        package: spi_device_pkg
        struct: passthrough_rsp
        signame: spi_device_passthrough_rsp
        width: 1
        type: req_rsp
        end_idx: -1
        act: req
        suffix: rsp
        default: spi_device_pkg::PASSTHROUGH_RSP_DEFAULT
      }
      {
        package: ""
        struct: logic
        signame: rv_dm_ndmreset_req
        width: 1
        type: uni
        end_idx: -1
        act: req
        suffix: ""
        default: "'0"
      }
      {
        package: prim_mubi_pkg
        struct: mubi4
        signame: rstmgr_aon_sw_rst_req
        width: 1
        type: uni
        end_idx: -1
        act: req
        suffix: ""
        default: prim_mubi_pkg::MUBI4_DEFAULT
      }
      {
        package: ""
        struct: logic
        signame: pwrmgr_aon_wakeups
        width: 3
        type: uni
        end_idx: -1
        act: rcv
        suffix: ""
        default: "'0"
      }
      {
        package: ""
        struct: logic
        signame: pwrmgr_aon_rstreqs
        width: 1
        type: uni
        end_idx: -1
        act: rcv
        suffix: ""
        default: "'0"
      }
      {
        package: tlul_pkg
        struct: tl_h2d
        signame: main_tl_rv_core_ibex__corei_req
        width: 1
        type: req_rsp
        end_idx: -1
        act: rsp
        suffix: req
        default: tlul_pkg::TL_H2D_DEFAULT
      }
      {
        package: tlul_pkg
        struct: tl_d2h
        signame: main_tl_rv_core_ibex__corei_rsp
        width: 1
        type: req_rsp
        end_idx: -1
        act: rsp
        suffix: rsp
        default: ""
      }
      {
        package: tlul_pkg
        struct: tl_h2d
        signame: main_tl_rv_core_ibex__cored_req
        width: 1
        type: req_rsp
        end_idx: -1
        act: rsp
        suffix: req
        default: tlul_pkg::TL_H2D_DEFAULT
      }
      {
        package: tlul_pkg
        struct: tl_d2h
        signame: main_tl_rv_core_ibex__cored_rsp
        width: 1
        type: req_rsp
        end_idx: -1
        act: rsp
        suffix: rsp
        default: ""
      }
      {
        package: tlul_pkg
        struct: tl_h2d
        signame: main_tl_rv_dm__sba_req
        width: 1
        type: req_rsp
        end_idx: -1
        act: rsp
        suffix: req
        default: tlul_pkg::TL_H2D_DEFAULT
      }
      {
        package: tlul_pkg
        struct: tl_d2h
        signame: main_tl_rv_dm__sba_rsp
        width: 1
        type: req_rsp
        end_idx: -1
        act: rsp
        suffix: rsp
        default: ""
      }
      {
        package: tlul_pkg
        struct: tl_h2d
        signame: rv_dm_regs_tl_d_req
        width: 1
        type: req_rsp
        end_idx: -1
        act: rsp
        suffix: req
        default: tlul_pkg::TL_H2D_DEFAULT
      }
      {
        package: tlul_pkg
        struct: tl_d2h
        signame: rv_dm_regs_tl_d_rsp
        width: 1
        type: req_rsp
        end_idx: -1
        act: rsp
        suffix: rsp
        default: ""
      }
      {
        package: tlul_pkg
        struct: tl_h2d
        signame: rv_dm_mem_tl_d_req
        width: 1
        type: req_rsp
        end_idx: -1
        act: rsp
        suffix: req
        default: tlul_pkg::TL_H2D_DEFAULT
      }
      {
        package: tlul_pkg
        struct: tl_d2h
        signame: rv_dm_mem_tl_d_rsp
        width: 1
        type: req_rsp
        end_idx: -1
        act: rsp
        suffix: rsp
        default: ""
      }
      {
        package: tlul_pkg
        struct: tl_h2d
        signame: rom_ctrl_rom_tl_req
        width: 1
        type: req_rsp
        end_idx: -1
        act: rsp
        suffix: req
        default: tlul_pkg::TL_H2D_DEFAULT
      }
      {
        package: tlul_pkg
        struct: tl_d2h
        signame: rom_ctrl_rom_tl_rsp
        width: 1
        type: req_rsp
        end_idx: -1
        act: rsp
        suffix: rsp
        default: ""
      }
      {
        package: tlul_pkg
        struct: tl_h2d
        signame: rom_ctrl_regs_tl_req
        width: 1
        type: req_rsp
        end_idx: -1
        act: rsp
        suffix: req
        default: tlul_pkg::TL_H2D_DEFAULT
      }
      {
        package: tlul_pkg
        struct: tl_d2h
        signame: rom_ctrl_regs_tl_rsp
        width: 1
        type: req_rsp
        end_idx: -1
        act: rsp
        suffix: rsp
        default: ""
      }
      {
        package: tlul_pkg
        struct: tl_h2d
        signame: main_tl_peri_req
        width: 1
        type: req_rsp
        end_idx: -1
        act: req
        suffix: req
        default: ""
      }
      {
        package: tlul_pkg
        struct: tl_d2h
        signame: main_tl_peri_rsp
        width: 1
        type: req_rsp
        end_idx: -1
        act: req
        suffix: rsp
        default: tlul_pkg::TL_D2H_DEFAULT
      }
      {
        package: tlul_pkg
        struct: tl_h2d
        signame: spi_host0_tl_req
        width: 1
        type: req_rsp
        end_idx: -1
        act: rsp
        suffix: req
        default: tlul_pkg::TL_H2D_DEFAULT
      }
      {
        package: tlul_pkg
        struct: tl_d2h
        signame: spi_host0_tl_rsp
        width: 1
        type: req_rsp
        end_idx: -1
        act: rsp
        suffix: rsp
        default: ""
      }
      {
        package: tlul_pkg
        struct: tl_h2d
        signame: flash_ctrl_core_tl_req
        width: 1
        type: req_rsp
        end_idx: -1
        act: rsp
        suffix: req
        default: tlul_pkg::TL_H2D_DEFAULT
      }
      {
        package: tlul_pkg
        struct: tl_d2h
        signame: flash_ctrl_core_tl_rsp
        width: 1
        type: req_rsp
        end_idx: -1
        act: rsp
        suffix: rsp
        default: ""
      }
      {
        package: tlul_pkg
        struct: tl_h2d
        signame: flash_ctrl_prim_tl_req
        width: 1
        type: req_rsp
        end_idx: -1
        act: rsp
        suffix: req
        default: tlul_pkg::TL_H2D_DEFAULT
      }
      {
        package: tlul_pkg
        struct: tl_d2h
        signame: flash_ctrl_prim_tl_rsp
        width: 1
        type: req_rsp
        end_idx: -1
        act: rsp
        suffix: rsp
        default: ""
      }
      {
        package: tlul_pkg
        struct: tl_h2d
        signame: flash_ctrl_mem_tl_req
        width: 1
        type: req_rsp
        end_idx: -1
        act: rsp
        suffix: req
        default: tlul_pkg::TL_H2D_DEFAULT
      }
      {
        package: tlul_pkg
        struct: tl_d2h
        signame: flash_ctrl_mem_tl_rsp
        width: 1
        type: req_rsp
        end_idx: -1
        act: rsp
        suffix: rsp
        default: ""
      }
      {
        package: tlul_pkg
        struct: tl_h2d
        signame: kmac_tl_req
        width: 1
        type: req_rsp
        end_idx: -1
        act: rsp
        suffix: req
        default: tlul_pkg::TL_H2D_DEFAULT
      }
      {
        package: tlul_pkg
        struct: tl_d2h
        signame: kmac_tl_rsp
        width: 1
        type: req_rsp
        end_idx: -1
        act: rsp
        suffix: rsp
        default: ""
      }
      {
        package: tlul_pkg
        struct: tl_h2d
        signame: entropy_src_tl_req
        width: 1
        type: req_rsp
        end_idx: -1
        act: rsp
        suffix: req
        default: tlul_pkg::TL_H2D_DEFAULT
      }
      {
        package: tlul_pkg
        struct: tl_d2h
        signame: entropy_src_tl_rsp
        width: 1
        type: req_rsp
        end_idx: -1
        act: rsp
        suffix: rsp
        default: ""
      }
      {
        package: tlul_pkg
        struct: tl_h2d
        signame: csrng_tl_req
        width: 1
        type: req_rsp
        end_idx: -1
        act: rsp
        suffix: req
        default: tlul_pkg::TL_H2D_DEFAULT
      }
      {
        package: tlul_pkg
        struct: tl_d2h
        signame: csrng_tl_rsp
        width: 1
        type: req_rsp
        end_idx: -1
        act: rsp
        suffix: rsp
        default: ""
      }
      {
        package: tlul_pkg
        struct: tl_h2d
        signame: edn0_tl_req
        width: 1
        type: req_rsp
        end_idx: -1
        act: rsp
        suffix: req
        default: tlul_pkg::TL_H2D_DEFAULT
      }
      {
        package: tlul_pkg
        struct: tl_d2h
        signame: edn0_tl_rsp
        width: 1
        type: req_rsp
        end_idx: -1
        act: rsp
        suffix: rsp
        default: ""
      }
      {
        package: tlul_pkg
        struct: tl_h2d
        signame: rv_plic_tl_req
        width: 1
        type: req_rsp
        end_idx: -1
        act: rsp
        suffix: req
        default: tlul_pkg::TL_H2D_DEFAULT
      }
      {
        package: tlul_pkg
        struct: tl_d2h
        signame: rv_plic_tl_rsp
        width: 1
        type: req_rsp
        end_idx: -1
        act: rsp
        suffix: rsp
        default: ""
      }
      {
        package: tlul_pkg
        struct: tl_h2d
        signame: keymgr_tl_req
        width: 1
        type: req_rsp
        end_idx: -1
        act: rsp
        suffix: req
        default: tlul_pkg::TL_H2D_DEFAULT
      }
      {
        package: tlul_pkg
        struct: tl_d2h
        signame: keymgr_tl_rsp
        width: 1
        type: req_rsp
        end_idx: -1
        act: rsp
        suffix: rsp
        default: ""
      }
      {
        package: tlul_pkg
        struct: tl_h2d
        signame: rv_core_ibex_cfg_tl_d_req
        width: 1
        type: req_rsp
        end_idx: -1
        act: rsp
        suffix: req
        default: tlul_pkg::TL_H2D_DEFAULT
      }
      {
        package: tlul_pkg
        struct: tl_d2h
        signame: rv_core_ibex_cfg_tl_d_rsp
        width: 1
        type: req_rsp
        end_idx: -1
        act: rsp
        suffix: rsp
        default: ""
      }
      {
        package: tlul_pkg
        struct: tl_h2d
        signame: sram_ctrl_main_regs_tl_req
        width: 1
        type: req_rsp
        end_idx: -1
        act: rsp
        suffix: req
        default: tlul_pkg::TL_H2D_DEFAULT
      }
      {
        package: tlul_pkg
        struct: tl_d2h
        signame: sram_ctrl_main_regs_tl_rsp
        width: 1
        type: req_rsp
        end_idx: -1
        act: rsp
        suffix: rsp
        default: ""
      }
      {
        package: tlul_pkg
        struct: tl_h2d
        signame: sram_ctrl_main_ram_tl_req
        width: 1
        type: req_rsp
        end_idx: -1
        act: rsp
        suffix: req
        default: tlul_pkg::TL_H2D_DEFAULT
      }
      {
        package: tlul_pkg
        struct: tl_d2h
        signame: sram_ctrl_main_ram_tl_rsp
        width: 1
        type: req_rsp
        end_idx: -1
        act: rsp
        suffix: rsp
        default: ""
      }
      {
        package: tlul_pkg
        struct: tl_h2d
        signame: ergo_cdc_bridge0_tl_req
        width: 1
        type: req_rsp
        end_idx: -1
        act: rsp
        suffix: req
        default: tlul_pkg::TL_H2D_DEFAULT
      }
      {
        package: tlul_pkg
        struct: tl_d2h
        signame: ergo_cdc_bridge0_tl_rsp
        width: 1
        type: req_rsp
        end_idx: -1
        act: rsp
        suffix: rsp
        default: ""
      }
      {
        package: tlul_pkg
        struct: tl_h2d
        signame: ergo_cdc_bridge1_tl_req
        width: 1
        type: req_rsp
        end_idx: -1
        act: rsp
        suffix: req
        default: tlul_pkg::TL_H2D_DEFAULT
      }
      {
        package: tlul_pkg
        struct: tl_d2h
        signame: ergo_cdc_bridge1_tl_rsp
        width: 1
        type: req_rsp
        end_idx: -1
        act: rsp
        suffix: rsp
        default: ""
      }
      {
        package: tlul_pkg
        struct: tl_h2d
        signame: ergo_cdc_bridge2_tl_req
        width: 1
        type: req_rsp
        end_idx: -1
        act: rsp
        suffix: req
        default: tlul_pkg::TL_H2D_DEFAULT
      }
      {
        package: tlul_pkg
        struct: tl_d2h
        signame: ergo_cdc_bridge2_tl_rsp
        width: 1
        type: req_rsp
        end_idx: -1
        act: rsp
        suffix: rsp
        default: ""
      }
      {
        package: tlul_pkg
        struct: tl_h2d
        signame: ergo_cdc_bridge3_tl_req
        width: 1
        type: req_rsp
        end_idx: -1
        act: rsp
        suffix: req
        default: tlul_pkg::TL_H2D_DEFAULT
      }
      {
        package: tlul_pkg
        struct: tl_d2h
        signame: ergo_cdc_bridge3_tl_rsp
        width: 1
        type: req_rsp
        end_idx: -1
        act: rsp
        suffix: rsp
        default: ""
      }
      {
        package: tlul_pkg
        struct: tl_h2d
        signame: ergo_cdc_bridge4_tl_req
        width: 1
        type: req_rsp
        end_idx: -1
        act: rsp
        suffix: req
        default: tlul_pkg::TL_H2D_DEFAULT
      }
      {
        package: tlul_pkg
        struct: tl_d2h
        signame: ergo_cdc_bridge4_tl_rsp
        width: 1
        type: req_rsp
        end_idx: -1
        act: rsp
        suffix: rsp
        default: ""
      }
      {
        package: tlul_pkg
        struct: tl_h2d
        signame: ergo_cdc_bridge5_tl_req
        width: 1
        type: req_rsp
        end_idx: -1
        act: rsp
        suffix: req
        default: tlul_pkg::TL_H2D_DEFAULT
      }
      {
        package: tlul_pkg
        struct: tl_d2h
        signame: ergo_cdc_bridge5_tl_rsp
        width: 1
        type: req_rsp
        end_idx: -1
        act: rsp
        suffix: rsp
        default: ""
      }
      {
        package: tlul_pkg
        struct: tl_h2d
        signame: ergo_setup_gen0_tl_req
        width: 1
        type: req_rsp
        end_idx: -1
        act: rsp
        suffix: req
        default: tlul_pkg::TL_H2D_DEFAULT
      }
      {
        package: tlul_pkg
        struct: tl_d2h
        signame: ergo_setup_gen0_tl_rsp
        width: 1
        type: req_rsp
        end_idx: -1
        act: rsp
        suffix: rsp
        default: ""
      }
      {
        package: tlul_pkg
        struct: tl_h2d
        signame: ergo_setup_gen1_tl_req
        width: 1
        type: req_rsp
        end_idx: -1
        act: rsp
        suffix: req
        default: tlul_pkg::TL_H2D_DEFAULT
      }
      {
        package: tlul_pkg
        struct: tl_d2h
        signame: ergo_setup_gen1_tl_rsp
        width: 1
        type: req_rsp
        end_idx: -1
        act: rsp
        suffix: rsp
        default: ""
      }
      {
        package: tlul_pkg
        struct: tl_h2d
        signame: ergo_setup_gen2_tl_req
        width: 1
        type: req_rsp
        end_idx: -1
        act: rsp
        suffix: req
        default: tlul_pkg::TL_H2D_DEFAULT
      }
      {
        package: tlul_pkg
        struct: tl_d2h
        signame: ergo_setup_gen2_tl_rsp
        width: 1
        type: req_rsp
        end_idx: -1
        act: rsp
        suffix: rsp
        default: ""
      }
      {
        package: tlul_pkg
        struct: tl_h2d
        signame: ergo_setup_gen3_tl_req
        width: 1
        type: req_rsp
        end_idx: -1
        act: rsp
        suffix: req
        default: tlul_pkg::TL_H2D_DEFAULT
      }
      {
        package: tlul_pkg
        struct: tl_d2h
        signame: ergo_setup_gen3_tl_rsp
        width: 1
        type: req_rsp
        end_idx: -1
        act: rsp
        suffix: rsp
        default: ""
      }
      {
        package: tlul_pkg
        struct: tl_h2d
        signame: ergo_setup_gen4_tl_req
        width: 1
        type: req_rsp
        end_idx: -1
        act: rsp
        suffix: req
        default: tlul_pkg::TL_H2D_DEFAULT
      }
      {
        package: tlul_pkg
        struct: tl_d2h
        signame: ergo_setup_gen4_tl_rsp
        width: 1
        type: req_rsp
        end_idx: -1
        act: rsp
        suffix: rsp
        default: ""
      }
      {
        package: tlul_pkg
        struct: tl_h2d
        signame: ergo_setup_gen5_tl_req
        width: 1
        type: req_rsp
        end_idx: -1
        act: rsp
        suffix: req
        default: tlul_pkg::TL_H2D_DEFAULT
      }
      {
        package: tlul_pkg
        struct: tl_d2h
        signame: ergo_setup_gen5_tl_rsp
        width: 1
        type: req_rsp
        end_idx: -1
        act: rsp
        suffix: rsp
        default: ""
      }
      {
        package: tlul_pkg
        struct: tl_h2d
        signame: ergo_hold_gen0_tl_req
        width: 1
        type: req_rsp
        end_idx: -1
        act: rsp
        suffix: req
        default: tlul_pkg::TL_H2D_DEFAULT
      }
      {
        package: tlul_pkg
        struct: tl_d2h
        signame: ergo_hold_gen0_tl_rsp
        width: 1
        type: req_rsp
        end_idx: -1
        act: rsp
        suffix: rsp
        default: ""
      }
      {
        package: tlul_pkg
        struct: tl_h2d
        signame: ergo_hold_gen1_tl_req
        width: 1
        type: req_rsp
        end_idx: -1
        act: rsp
        suffix: req
        default: tlul_pkg::TL_H2D_DEFAULT
      }
      {
        package: tlul_pkg
        struct: tl_d2h
        signame: ergo_hold_gen1_tl_rsp
        width: 1
        type: req_rsp
        end_idx: -1
        act: rsp
        suffix: rsp
        default: ""
      }
      {
        package: tlul_pkg
        struct: tl_h2d
        signame: ergo_hold_gen2_tl_req
        width: 1
        type: req_rsp
        end_idx: -1
        act: rsp
        suffix: req
        default: tlul_pkg::TL_H2D_DEFAULT
      }
      {
        package: tlul_pkg
        struct: tl_d2h
        signame: ergo_hold_gen2_tl_rsp
        width: 1
        type: req_rsp
        end_idx: -1
        act: rsp
        suffix: rsp
        default: ""
      }
      {
        package: tlul_pkg
        struct: tl_h2d
        signame: ergo_hold_gen3_tl_req
        width: 1
        type: req_rsp
        end_idx: -1
        act: rsp
        suffix: req
        default: tlul_pkg::TL_H2D_DEFAULT
      }
      {
        package: tlul_pkg
        struct: tl_d2h
        signame: ergo_hold_gen3_tl_rsp
        width: 1
        type: req_rsp
        end_idx: -1
        act: rsp
        suffix: rsp
        default: ""
      }
      {
        package: tlul_pkg
        struct: tl_h2d
        signame: ergo_hold_gen4_tl_req
        width: 1
        type: req_rsp
        end_idx: -1
        act: rsp
        suffix: req
        default: tlul_pkg::TL_H2D_DEFAULT
      }
      {
        package: tlul_pkg
        struct: tl_d2h
        signame: ergo_hold_gen4_tl_rsp
        width: 1
        type: req_rsp
        end_idx: -1
        act: rsp
        suffix: rsp
        default: ""
      }
      {
        package: tlul_pkg
        struct: tl_h2d
        signame: ergo_cdc_hazard_gen0_tl_req
        width: 1
        type: req_rsp
        end_idx: -1
        act: rsp
        suffix: req
        default: tlul_pkg::TL_H2D_DEFAULT
      }
      {
        package: tlul_pkg
        struct: tl_d2h
        signame: ergo_cdc_hazard_gen0_tl_rsp
        width: 1
        type: req_rsp
        end_idx: -1
        act: rsp
        suffix: rsp
        default: ""
      }
      {
        package: tlul_pkg
        struct: tl_h2d
        signame: ergo_cdc_hazard_gen1_tl_req
        width: 1
        type: req_rsp
        end_idx: -1
        act: rsp
        suffix: req
        default: tlul_pkg::TL_H2D_DEFAULT
      }
      {
        package: tlul_pkg
        struct: tl_d2h
        signame: ergo_cdc_hazard_gen1_tl_rsp
        width: 1
        type: req_rsp
        end_idx: -1
        act: rsp
        suffix: rsp
        default: ""
      }
      {
        package: tlul_pkg
        struct: tl_h2d
        signame: ergo_cdc_hazard_gen2_tl_req
        width: 1
        type: req_rsp
        end_idx: -1
        act: rsp
        suffix: req
        default: tlul_pkg::TL_H2D_DEFAULT
      }
      {
        package: tlul_pkg
        struct: tl_d2h
        signame: ergo_cdc_hazard_gen2_tl_rsp
        width: 1
        type: req_rsp
        end_idx: -1
        act: rsp
        suffix: rsp
        default: ""
      }
      {
        package: tlul_pkg
        struct: tl_h2d
        signame: ergo_cdc_hazard_gen3_tl_req
        width: 1
        type: req_rsp
        end_idx: -1
        act: rsp
        suffix: req
        default: tlul_pkg::TL_H2D_DEFAULT
      }
      {
        package: tlul_pkg
        struct: tl_d2h
        signame: ergo_cdc_hazard_gen3_tl_rsp
        width: 1
        type: req_rsp
        end_idx: -1
        act: rsp
        suffix: rsp
        default: ""
      }
      {
        package: tlul_pkg
        struct: tl_h2d
        signame: ergo_cdc_hazard_gen4_tl_req
        width: 1
        type: req_rsp
        end_idx: -1
        act: rsp
        suffix: req
        default: tlul_pkg::TL_H2D_DEFAULT
      }
      {
        package: tlul_pkg
        struct: tl_d2h
        signame: ergo_cdc_hazard_gen4_tl_rsp
        width: 1
        type: req_rsp
        end_idx: -1
        act: rsp
        suffix: rsp
        default: ""
      }
      {
        package: tlul_pkg
        struct: tl_h2d
        signame: ergo_cdc_bridge6_tl_req
        width: 1
        type: req_rsp
        end_idx: -1
        act: rsp
        suffix: req
        default: tlul_pkg::TL_H2D_DEFAULT
      }
      {
        package: tlul_pkg
        struct: tl_d2h
        signame: ergo_cdc_bridge6_tl_rsp
        width: 1
        type: req_rsp
        end_idx: -1
        act: rsp
        suffix: rsp
        default: ""
      }
      {
        package: tlul_pkg
        struct: tl_h2d
        signame: ergo_cdc_bridge7_tl_req
        width: 1
        type: req_rsp
        end_idx: -1
        act: rsp
        suffix: req
        default: tlul_pkg::TL_H2D_DEFAULT
      }
      {
        package: tlul_pkg
        struct: tl_d2h
        signame: ergo_cdc_bridge7_tl_rsp
        width: 1
        type: req_rsp
        end_idx: -1
        act: rsp
        suffix: rsp
        default: ""
      }
      {
        package: tlul_pkg
        struct: tl_h2d
        signame: ergo_cdc_bridge8_tl_req
        width: 1
        type: req_rsp
        end_idx: -1
        act: rsp
        suffix: req
        default: tlul_pkg::TL_H2D_DEFAULT
      }
      {
        package: tlul_pkg
        struct: tl_d2h
        signame: ergo_cdc_bridge8_tl_rsp
        width: 1
        type: req_rsp
        end_idx: -1
        act: rsp
        suffix: rsp
        default: ""
      }
      {
        package: tlul_pkg
        struct: tl_h2d
        signame: ergo_setup_gen6_tl_req
        width: 1
        type: req_rsp
        end_idx: -1
        act: rsp
        suffix: req
        default: tlul_pkg::TL_H2D_DEFAULT
      }
      {
        package: tlul_pkg
        struct: tl_d2h
        signame: ergo_setup_gen6_tl_rsp
        width: 1
        type: req_rsp
        end_idx: -1
        act: rsp
        suffix: rsp
        default: ""
      }
      {
        package: tlul_pkg
        struct: tl_h2d
        signame: ergo_setup_gen7_tl_req
        width: 1
        type: req_rsp
        end_idx: -1
        act: rsp
        suffix: req
        default: tlul_pkg::TL_H2D_DEFAULT
      }
      {
        package: tlul_pkg
        struct: tl_d2h
        signame: ergo_setup_gen7_tl_rsp
        width: 1
        type: req_rsp
        end_idx: -1
        act: rsp
        suffix: rsp
        default: ""
      }
      {
        package: tlul_pkg
        struct: tl_h2d
        signame: ergo_setup_gen8_tl_req
        width: 1
        type: req_rsp
        end_idx: -1
        act: rsp
        suffix: req
        default: tlul_pkg::TL_H2D_DEFAULT
      }
      {
        package: tlul_pkg
        struct: tl_d2h
        signame: ergo_setup_gen8_tl_rsp
        width: 1
        type: req_rsp
        end_idx: -1
        act: rsp
        suffix: rsp
        default: ""
      }
      {
        package: tlul_pkg
        struct: tl_h2d
        signame: ergo_hold_gen5_tl_req
        width: 1
        type: req_rsp
        end_idx: -1
        act: rsp
        suffix: req
        default: tlul_pkg::TL_H2D_DEFAULT
      }
      {
        package: tlul_pkg
        struct: tl_d2h
        signame: ergo_hold_gen5_tl_rsp
        width: 1
        type: req_rsp
        end_idx: -1
        act: rsp
        suffix: rsp
        default: ""
      }
      {
        package: tlul_pkg
        struct: tl_h2d
        signame: ergo_hold_gen6_tl_req
        width: 1
        type: req_rsp
        end_idx: -1
        act: rsp
        suffix: req
        default: tlul_pkg::TL_H2D_DEFAULT
      }
      {
        package: tlul_pkg
        struct: tl_d2h
        signame: ergo_hold_gen6_tl_rsp
        width: 1
        type: req_rsp
        end_idx: -1
        act: rsp
        suffix: rsp
        default: ""
      }
      {
        package: tlul_pkg
        struct: tl_h2d
        signame: ergo_cdc_hazard_gen5_tl_req
        width: 1
        type: req_rsp
        end_idx: -1
        act: rsp
        suffix: req
        default: tlul_pkg::TL_H2D_DEFAULT
      }
      {
        package: tlul_pkg
        struct: tl_d2h
        signame: ergo_cdc_hazard_gen5_tl_rsp
        width: 1
        type: req_rsp
        end_idx: -1
        act: rsp
        suffix: rsp
        default: ""
      }
      {
        package: tlul_pkg
        struct: tl_h2d
        signame: ergo_cdc_hazard_gen6_tl_req
        width: 1
        type: req_rsp
        end_idx: -1
        act: rsp
        suffix: req
        default: tlul_pkg::TL_H2D_DEFAULT
      }
      {
        package: tlul_pkg
        struct: tl_d2h
        signame: ergo_cdc_hazard_gen6_tl_rsp
        width: 1
        type: req_rsp
        end_idx: -1
        act: rsp
        suffix: rsp
        default: ""
      }
      {
        package: tlul_pkg
        struct: tl_h2d
        signame: uart0_tl_req
        width: 1
        type: req_rsp
        end_idx: -1
        act: rsp
        suffix: req
        default: tlul_pkg::TL_H2D_DEFAULT
      }
      {
        package: tlul_pkg
        struct: tl_d2h
        signame: uart0_tl_rsp
        width: 1
        type: req_rsp
        end_idx: -1
        act: rsp
        suffix: rsp
        default: ""
      }
      {
        package: tlul_pkg
        struct: tl_h2d
        signame: i2c0_tl_req
        width: 1
        type: req_rsp
        end_idx: -1
        act: rsp
        suffix: req
        default: tlul_pkg::TL_H2D_DEFAULT
      }
      {
        package: tlul_pkg
        struct: tl_d2h
        signame: i2c0_tl_rsp
        width: 1
        type: req_rsp
        end_idx: -1
        act: rsp
        suffix: rsp
        default: ""
      }
      {
        package: tlul_pkg
        struct: tl_h2d
        signame: gpio_tl_req
        width: 1
        type: req_rsp
        end_idx: -1
        act: rsp
        suffix: req
        default: tlul_pkg::TL_H2D_DEFAULT
      }
      {
        package: tlul_pkg
        struct: tl_d2h
        signame: gpio_tl_rsp
        width: 1
        type: req_rsp
        end_idx: -1
        act: rsp
        suffix: rsp
        default: ""
      }
      {
        package: tlul_pkg
        struct: tl_h2d
        signame: spi_device_tl_req
        width: 1
        type: req_rsp
        end_idx: -1
        act: rsp
        suffix: req
        default: tlul_pkg::TL_H2D_DEFAULT
      }
      {
        package: tlul_pkg
        struct: tl_d2h
        signame: spi_device_tl_rsp
        width: 1
        type: req_rsp
        end_idx: -1
        act: rsp
        suffix: rsp
        default: ""
      }
      {
        package: tlul_pkg
        struct: tl_h2d
        signame: rv_timer_tl_req
        width: 1
        type: req_rsp
        end_idx: -1
        act: rsp
        suffix: req
        default: tlul_pkg::TL_H2D_DEFAULT
      }
      {
        package: tlul_pkg
        struct: tl_d2h
        signame: rv_timer_tl_rsp
        width: 1
        type: req_rsp
        end_idx: -1
        act: rsp
        suffix: rsp
        default: ""
      }
      {
        package: tlul_pkg
        struct: tl_h2d
        signame: pwrmgr_aon_tl_req
        width: 1
        type: req_rsp
        end_idx: -1
        act: rsp
        suffix: req
        default: tlul_pkg::TL_H2D_DEFAULT
      }
      {
        package: tlul_pkg
        struct: tl_d2h
        signame: pwrmgr_aon_tl_rsp
        width: 1
        type: req_rsp
        end_idx: -1
        act: rsp
        suffix: rsp
        default: ""
      }
      {
        package: tlul_pkg
        struct: tl_h2d
        signame: rstmgr_aon_tl_req
        width: 1
        type: req_rsp
        end_idx: -1
        act: rsp
        suffix: req
        default: tlul_pkg::TL_H2D_DEFAULT
      }
      {
        package: tlul_pkg
        struct: tl_d2h
        signame: rstmgr_aon_tl_rsp
        width: 1
        type: req_rsp
        end_idx: -1
        act: rsp
        suffix: rsp
        default: ""
      }
      {
        package: tlul_pkg
        struct: tl_h2d
        signame: clkmgr_aon_tl_req
        width: 1
        type: req_rsp
        end_idx: -1
        act: rsp
        suffix: req
        default: tlul_pkg::TL_H2D_DEFAULT
      }
      {
        package: tlul_pkg
        struct: tl_d2h
        signame: clkmgr_aon_tl_rsp
        width: 1
        type: req_rsp
        end_idx: -1
        act: rsp
        suffix: rsp
        default: ""
      }
      {
        package: tlul_pkg
        struct: tl_h2d
        signame: pinmux_aon_tl_req
        width: 1
        type: req_rsp
        end_idx: -1
        act: rsp
        suffix: req
        default: tlul_pkg::TL_H2D_DEFAULT
      }
      {
        package: tlul_pkg
        struct: tl_d2h
        signame: pinmux_aon_tl_rsp
        width: 1
        type: req_rsp
        end_idx: -1
        act: rsp
        suffix: rsp
        default: ""
      }
      {
        package: tlul_pkg
        struct: tl_h2d
        signame: otp_ctrl_core_tl_req
        width: 1
        type: req_rsp
        end_idx: -1
        act: rsp
        suffix: req
        default: tlul_pkg::TL_H2D_DEFAULT
      }
      {
        package: tlul_pkg
        struct: tl_d2h
        signame: otp_ctrl_core_tl_rsp
        width: 1
        type: req_rsp
        end_idx: -1
        act: rsp
        suffix: rsp
        default: ""
      }
      {
        package: tlul_pkg
        struct: tl_h2d
        signame: otp_ctrl_prim_tl_req
        width: 1
        type: req_rsp
        end_idx: -1
        act: rsp
        suffix: req
        default: tlul_pkg::TL_H2D_DEFAULT
      }
      {
        package: tlul_pkg
        struct: tl_d2h
        signame: otp_ctrl_prim_tl_rsp
        width: 1
        type: req_rsp
        end_idx: -1
        act: rsp
        suffix: rsp
        default: ""
      }
      {
        package: tlul_pkg
        struct: tl_h2d
        signame: lc_ctrl_tl_req
        width: 1
        type: req_rsp
        end_idx: -1
        act: rsp
        suffix: req
        default: tlul_pkg::TL_H2D_DEFAULT
      }
      {
        package: tlul_pkg
        struct: tl_d2h
        signame: lc_ctrl_tl_rsp
        width: 1
        type: req_rsp
        end_idx: -1
        act: rsp
        suffix: rsp
        default: ""
      }
      {
        package: tlul_pkg
        struct: tl_h2d
        signame: alert_handler_tl_req
        width: 1
        type: req_rsp
        end_idx: -1
        act: rsp
        suffix: req
        default: tlul_pkg::TL_H2D_DEFAULT
      }
      {
        package: tlul_pkg
        struct: tl_d2h
        signame: alert_handler_tl_rsp
        width: 1
        type: req_rsp
        end_idx: -1
        act: rsp
        suffix: rsp
        default: ""
      }
      {
        package: tlul_pkg
        struct: tl_h2d
        signame: sram_ctrl_ret_aon_regs_tl_req
        width: 1
        type: req_rsp
        end_idx: -1
        act: rsp
        suffix: req
        default: tlul_pkg::TL_H2D_DEFAULT
      }
      {
        package: tlul_pkg
        struct: tl_d2h
        signame: sram_ctrl_ret_aon_regs_tl_rsp
        width: 1
        type: req_rsp
        end_idx: -1
        act: rsp
        suffix: rsp
        default: ""
      }
      {
        package: tlul_pkg
        struct: tl_h2d
        signame: sram_ctrl_ret_aon_ram_tl_req
        width: 1
        type: req_rsp
        end_idx: -1
        act: rsp
        suffix: req
        default: tlul_pkg::TL_H2D_DEFAULT
      }
      {
        package: tlul_pkg
        struct: tl_d2h
        signame: sram_ctrl_ret_aon_ram_tl_rsp
        width: 1
        type: req_rsp
        end_idx: -1
        act: rsp
        suffix: rsp
        default: ""
      }
      {
        package: tlul_pkg
        struct: tl_h2d
        signame: aon_timer_aon_tl_req
        width: 1
        type: req_rsp
        end_idx: -1
        act: rsp
        suffix: req
        default: tlul_pkg::TL_H2D_DEFAULT
      }
      {
        package: tlul_pkg
        struct: tl_d2h
        signame: aon_timer_aon_tl_rsp
        width: 1
        type: req_rsp
        end_idx: -1
        act: rsp
        suffix: rsp
        default: ""
      }
      {
        package: clkmgr_pkg
        struct: clkmgr_out
        signame: clkmgr_aon_clocks
        width: 1
        type: uni
        end_idx: -1
        default: ""
      }
      {
        package: clkmgr_pkg
        struct: clkmgr_cg_en
        signame: clkmgr_aon_cg_en
        width: 1
        type: uni
        end_idx: -1
        default: ""
      }
      {
        package: rstmgr_pkg
        struct: rstmgr_out
        signame: rstmgr_aon_resets
        width: 1
        type: uni
        end_idx: -1
        default: ""
      }
      {
        package: rstmgr_pkg
        struct: rstmgr_rst_en
        signame: rstmgr_aon_rst_en
        width: 1
        type: uni
        end_idx: -1
        default: ""
      }
      {
        package: ""
        struct: logic
        signame: rv_core_ibex_irq_timer
        width: 1
        type: uni
        end_idx: -1
        default: ""
      }
      {
        package: ""
        struct: logic
        signame: rv_core_ibex_hart_id
        width: 32
        type: uni
        end_idx: -1
        default: ""
      }
      {
        package: ""
        struct: logic
        signame: rv_core_ibex_boot_addr
        width: 32
        type: uni
        end_idx: -1
        default: ""
      }
      {
        package: jtag_pkg
        struct: jtag_req
        signame: pinmux_aon_dft_jtag_req
        width: 1
        type: req_rsp
        end_idx: -1
        default: ""
      }
      {
        package: jtag_pkg
        struct: jtag_rsp
        signame: pinmux_aon_dft_jtag_rsp
        width: 1
        type: req_rsp
        end_idx: -1
        default: ""
      }
      {
        package: otp_ctrl_part_pkg
        struct: otp_broadcast
        signame: otp_ctrl_otp_broadcast
        width: 1
        type: uni
        end_idx: -1
        default: "'0"
      }
      {
        package: prim_mubi_pkg
        struct: mubi8
        signame: csrng_otp_en_csrng_sw_app_read
        width: 1
        type: uni
        end_idx: -1
        default: prim_mubi_pkg::MuBi8True
      }
      {
        package: otp_ctrl_pkg
        struct: otp_device_id
        signame: lc_ctrl_otp_device_id
        width: 1
        type: uni
        end_idx: -1
        default: "'0"
      }
      {
        package: otp_ctrl_pkg
        struct: otp_manuf_state
        signame: lc_ctrl_otp_manuf_state
        width: 1
        type: uni
        end_idx: -1
        default: "'0"
      }
      {
        package: otp_ctrl_pkg
        struct: otp_device_id
        signame: keymgr_otp_device_id
        width: 1
        type: uni
        end_idx: -1
        default: ""
      }
      {
        package: prim_mubi_pkg
        struct: mubi8
        signame: sram_ctrl_main_otp_en_sram_ifetch
        width: 1
        type: uni
        end_idx: -1
        default: prim_mubi_pkg::MuBi8False
      }
      {
        package: prim_mubi_pkg
        struct: mubi8
        signame: rv_dm_otp_dis_rv_dm_late_debug
        width: 1
        type: uni
        end_idx: -1
        default: prim_mubi_pkg::MuBi8False
      }
    ]
  }
}
